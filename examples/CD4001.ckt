* CD4001B Full Analog Model
* Tim Williams, 2017-10-17
* Should cover pretty much everything.
* Not tested over temperature, but the transistor model
* used should give good results.
*
.SUBCKT CD4001_AN A B Y VDD VSS

D1 VSS VDD ESD-D
Q1 VDD VSS A ESDVSS
MQ2 NetQ2_1 A VDD VDD RIT4007P7 L=10u W=20u AD=200p AS=200p PD=60u PS=60u NRD=0.1 NRS=0.1
MQ3 NetQ2_1 A VSS VSS RIT4007N7 L=10u W=10u AD=100p AS=100p PD=40u PS=40u NRD=0.54 NRS=0.54
Q4 VSS VDD A ESDVDD
MQ5 NetQ5_1 NetQ2_1 VDD VDD RIT4007P7 L=10u W=20u AD=200p AS=200p PD=60u PS=60u NRD=0.1 NRS=0.1
MQ6 NetQ5_1 NetQ6_2 VDD VDD RIT4007P7 L=10u W=20u AD=200p AS=200p PD=60u PS=60u NRD=0.1 NRS=0.1
MQ7 Y NetQ5_1 VDD VDD RIT4007P7 L=10u W=360u AD=18n AS=18n PD=820u PS=820u NRD=0.1 NRS=0.1
Q8 B VDD A ESDIN
Q9 VDD VSS B ESDVSS
MQ10 NetQ6_2 B VDD VDD RIT4007P7 L=10u W=20u AD=200p AS=200p PD=60u PS=60u NRD=0.1 NRS=0.1
MQ11 NetQ5_1 NetQ6_2 NetQ11_3 NetQ11_3 RIT4007N7 L=10u W=10u AD=100p AS=100p PD=40u PS=40u NRD=0.54 NRS=0.54
MQ12 Y NetQ5_1 VSS VSS RIT4007N7 L=10u W=170u AD=8.5n AS=8.5n PD=440u PS=440u NRD=0.54 NRS=0.54
MQ13 NetQ6_2 B VSS VSS RIT4007N7 L=10u W=10u AD=100p AS=100p PD=40u PS=40u NRD=0.54 NRS=0.54
Q14 VSS VDD B ESDVDD
MQ15 NetQ11_3 NetQ2_1 VSS VSS RIT4007N7 L=10u W=10u AD=100p AS=100p PD=40u PS=40u NRD=0.54 NRS=0.54

* Models and Subcircuits
.MODEL ESD-D D ( IS=1n N=2.1 RS=4.4 TT=10n )

.MODEL ESDVSS NPN ( IS=113p BF=200   IKF=10m ISE=100p BR=5     RB=5 TF=10n TR=100n )
.MODEL ESDVDD PNP ( IS=100p BF=0.5   IKF=10m ISE=100p BR=0.5   RB=5 TF=10n TR=10n  )
.MODEL ESDIN  PNP ( IS=100p BF=0.035 IKF=10m ISE=100p BR=0.035 RB=5 TF=10n TR=10n  )

.MODEL RIT4007P7 PMOS (LEVEL=7 VERSION=3.1 CAPMOD=2 MOBMOD=1 TOX=5E-8 XJ=2.26E-7
+ NCH=1E15 NSUB=8E14 XT=8.66E-8 VTH0=-1.65 U0=400 WINT=1.0E-6 LINT=1E-6 NGATE=5E20
+ RSH=1347 JS=3.51E-8 JSW=3.51E-8 CJ=5.28E-8 MJ=0.5 PB=0.94 CJSW=1.19E-10 MJSW=0.5
+ PBSW=0.94 PCLM=5 CGSO=4.5E-10 CGDO=4.5E-10 CGBO=5.75E-10)

.MODEL RIT4007N7 NMOS (LEVEL=7 VERSION=3.1 CAPMOD=2 MOBMOD=1 TOX=4E-8 XJ=2.9E-7
+ NCH=4E15 NSUB=5.33E15 XT=8.66E-8 VTH0=1.4 U0=1300 WINT=2.0E-7 LINT=1E-7
+ NGATE=5E20 RSH=300 JS=3.23E-8 JSW=3.23E-8 CJ=6.8E-8 MJ=0.5 PB=0.95 CJSW=1.26E-10
+ MJSW=0.5 PBSW=0.95 PCLM=5 CGSO=3.4E-10 CGDO=3.4E-10 CGBO=5.75E-10)

.ENDS
