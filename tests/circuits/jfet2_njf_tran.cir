JFET2 NJF Transient
* Common-source NJF switching transient with JFET2 LEVEL=2
Vdd vdd 0 5
Rd vdd drain 1k
J1 drain gate 0 JMOD
Vg gate 0 PULSE(-2 0 0 1n 1n 5u 10u)
.model JMOD NJF LEVEL=2 VTO=-2 BETA=1e-4 LAMBDA=0.02 IS=1e-14 RD=10 RS=10
+ CGS=5e-12 CGD=1e-12 PB=1.0 FC=0.5
.tran 0.1u 20u
.end
