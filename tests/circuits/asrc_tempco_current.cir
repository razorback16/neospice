ASRC temperature coefficient test - current mode
* B current source with tc1 and tc2 at TEMP=100
V1 in 0 DC 5.0
R1 out 0 1k
B1 0 out I={V(in)*1e-3} tc1=0.001 tc2=0.00001
.options TEMP=100
.op
.end
