Matched lossless ltra_lc external resistor noise
V1 drive 0 DC 0 AC 1
Rs drive in 50
O1 in 0 out 0 TMOD
.model TMOD LTRA L=250n C=100p LEN=1
Rl out 0 50
.noise V(out) V1 DEC 4 1k 10g
.end
