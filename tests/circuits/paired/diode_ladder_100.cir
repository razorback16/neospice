* diode ladder, 100 stages
.model DMOD D(IS=1e-14 N=1.0)
Vin in 0 DC 5
Rin in n0 1k
D0 n0 n1 DMOD
Rs0 n1 0 10k
D1 n1 n2 DMOD
Rs1 n2 0 10k
D2 n2 n3 DMOD
Rs2 n3 0 10k
D3 n3 n4 DMOD
Rs3 n4 0 10k
D4 n4 n5 DMOD
Rs4 n5 0 10k
D5 n5 n6 DMOD
Rs5 n6 0 10k
D6 n6 n7 DMOD
Rs6 n7 0 10k
D7 n7 n8 DMOD
Rs7 n8 0 10k
D8 n8 n9 DMOD
Rs8 n9 0 10k
D9 n9 n10 DMOD
Rs9 n10 0 10k
D10 n10 n11 DMOD
Rs10 n11 0 10k
D11 n11 n12 DMOD
Rs11 n12 0 10k
D12 n12 n13 DMOD
Rs12 n13 0 10k
D13 n13 n14 DMOD
Rs13 n14 0 10k
D14 n14 n15 DMOD
Rs14 n15 0 10k
D15 n15 n16 DMOD
Rs15 n16 0 10k
D16 n16 n17 DMOD
Rs16 n17 0 10k
D17 n17 n18 DMOD
Rs17 n18 0 10k
D18 n18 n19 DMOD
Rs18 n19 0 10k
D19 n19 n20 DMOD
Rs19 n20 0 10k
D20 n20 n21 DMOD
Rs20 n21 0 10k
D21 n21 n22 DMOD
Rs21 n22 0 10k
D22 n22 n23 DMOD
Rs22 n23 0 10k
D23 n23 n24 DMOD
Rs23 n24 0 10k
D24 n24 n25 DMOD
Rs24 n25 0 10k
D25 n25 n26 DMOD
Rs25 n26 0 10k
D26 n26 n27 DMOD
Rs26 n27 0 10k
D27 n27 n28 DMOD
Rs27 n28 0 10k
D28 n28 n29 DMOD
Rs28 n29 0 10k
D29 n29 n30 DMOD
Rs29 n30 0 10k
D30 n30 n31 DMOD
Rs30 n31 0 10k
D31 n31 n32 DMOD
Rs31 n32 0 10k
D32 n32 n33 DMOD
Rs32 n33 0 10k
D33 n33 n34 DMOD
Rs33 n34 0 10k
D34 n34 n35 DMOD
Rs34 n35 0 10k
D35 n35 n36 DMOD
Rs35 n36 0 10k
D36 n36 n37 DMOD
Rs36 n37 0 10k
D37 n37 n38 DMOD
Rs37 n38 0 10k
D38 n38 n39 DMOD
Rs38 n39 0 10k
D39 n39 n40 DMOD
Rs39 n40 0 10k
D40 n40 n41 DMOD
Rs40 n41 0 10k
D41 n41 n42 DMOD
Rs41 n42 0 10k
D42 n42 n43 DMOD
Rs42 n43 0 10k
D43 n43 n44 DMOD
Rs43 n44 0 10k
D44 n44 n45 DMOD
Rs44 n45 0 10k
D45 n45 n46 DMOD
Rs45 n46 0 10k
D46 n46 n47 DMOD
Rs46 n47 0 10k
D47 n47 n48 DMOD
Rs47 n48 0 10k
D48 n48 n49 DMOD
Rs48 n49 0 10k
D49 n49 n50 DMOD
Rs49 n50 0 10k
D50 n50 n51 DMOD
Rs50 n51 0 10k
D51 n51 n52 DMOD
Rs51 n52 0 10k
D52 n52 n53 DMOD
Rs52 n53 0 10k
D53 n53 n54 DMOD
Rs53 n54 0 10k
D54 n54 n55 DMOD
Rs54 n55 0 10k
D55 n55 n56 DMOD
Rs55 n56 0 10k
D56 n56 n57 DMOD
Rs56 n57 0 10k
D57 n57 n58 DMOD
Rs57 n58 0 10k
D58 n58 n59 DMOD
Rs58 n59 0 10k
D59 n59 n60 DMOD
Rs59 n60 0 10k
D60 n60 n61 DMOD
Rs60 n61 0 10k
D61 n61 n62 DMOD
Rs61 n62 0 10k
D62 n62 n63 DMOD
Rs62 n63 0 10k
D63 n63 n64 DMOD
Rs63 n64 0 10k
D64 n64 n65 DMOD
Rs64 n65 0 10k
D65 n65 n66 DMOD
Rs65 n66 0 10k
D66 n66 n67 DMOD
Rs66 n67 0 10k
D67 n67 n68 DMOD
Rs67 n68 0 10k
D68 n68 n69 DMOD
Rs68 n69 0 10k
D69 n69 n70 DMOD
Rs69 n70 0 10k
D70 n70 n71 DMOD
Rs70 n71 0 10k
D71 n71 n72 DMOD
Rs71 n72 0 10k
D72 n72 n73 DMOD
Rs72 n73 0 10k
D73 n73 n74 DMOD
Rs73 n74 0 10k
D74 n74 n75 DMOD
Rs74 n75 0 10k
D75 n75 n76 DMOD
Rs75 n76 0 10k
D76 n76 n77 DMOD
Rs76 n77 0 10k
D77 n77 n78 DMOD
Rs77 n78 0 10k
D78 n78 n79 DMOD
Rs78 n79 0 10k
D79 n79 n80 DMOD
Rs79 n80 0 10k
D80 n80 n81 DMOD
Rs80 n81 0 10k
D81 n81 n82 DMOD
Rs81 n82 0 10k
D82 n82 n83 DMOD
Rs82 n83 0 10k
D83 n83 n84 DMOD
Rs83 n84 0 10k
D84 n84 n85 DMOD
Rs84 n85 0 10k
D85 n85 n86 DMOD
Rs85 n86 0 10k
D86 n86 n87 DMOD
Rs86 n87 0 10k
D87 n87 n88 DMOD
Rs87 n88 0 10k
D88 n88 n89 DMOD
Rs88 n89 0 10k
D89 n89 n90 DMOD
Rs89 n90 0 10k
D90 n90 n91 DMOD
Rs90 n91 0 10k
D91 n91 n92 DMOD
Rs91 n92 0 10k
D92 n92 n93 DMOD
Rs92 n93 0 10k
D93 n93 n94 DMOD
Rs93 n94 0 10k
D94 n94 n95 DMOD
Rs94 n95 0 10k
D95 n95 n96 DMOD
Rs95 n96 0 10k
D96 n96 n97 DMOD
Rs96 n97 0 10k
D97 n97 n98 DMOD
Rs97 n98 0 10k
D98 n98 n99 DMOD
Rs98 n99 0 10k
D99 n99 n100 DMOD
Rs99 n100 0 10k
.op
.end
