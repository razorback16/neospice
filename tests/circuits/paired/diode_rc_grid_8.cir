* synthetic diode_rc grid 8x8
V1 in 0 DC 0.8 AC 1 PULSE(0.2 0.8 0 10u 10u 50u 100u)
Rfeed in n0_0 1k
.model DGRID D(IS=1e-12 N=1.2 RS=2 CJO=1p M=0.4 TT=1n)
Rh0_0 n0_0 n1_0 1k
Rv0_0 n0_0 n0_1 1k
C0_0 n0_0 0 1n
D0_0 n0_0 0 DGRID
Rh1_0 n1_0 n2_0 1k
Rv1_0 n1_0 n1_1 1k
C1_0 n1_0 0 1n
D1_0 n1_0 0 DGRID
Rh2_0 n2_0 n3_0 1k
Rv2_0 n2_0 n2_1 1k
C2_0 n2_0 0 1n
D2_0 n2_0 0 DGRID
Rh3_0 n3_0 n4_0 1k
Rv3_0 n3_0 n3_1 1k
C3_0 n3_0 0 1n
D3_0 n3_0 0 DGRID
Rh4_0 n4_0 n5_0 1k
Rv4_0 n4_0 n4_1 1k
C4_0 n4_0 0 1n
D4_0 n4_0 0 DGRID
Rh5_0 n5_0 n6_0 1k
Rv5_0 n5_0 n5_1 1k
C5_0 n5_0 0 1n
D5_0 n5_0 0 DGRID
Rh6_0 n6_0 n7_0 1k
Rv6_0 n6_0 n6_1 1k
C6_0 n6_0 0 1n
D6_0 n6_0 0 DGRID
Rv7_0 n7_0 n7_1 1k
C7_0 n7_0 0 1n
D7_0 n7_0 0 DGRID
Rh0_1 n0_1 n1_1 1k
Rv0_1 n0_1 n0_2 1k
C0_1 n0_1 0 1n
D0_1 n0_1 0 DGRID
Rh1_1 n1_1 n2_1 1k
Rv1_1 n1_1 n1_2 1k
C1_1 n1_1 0 1n
D1_1 n1_1 0 DGRID
Rh2_1 n2_1 n3_1 1k
Rv2_1 n2_1 n2_2 1k
C2_1 n2_1 0 1n
D2_1 n2_1 0 DGRID
Rh3_1 n3_1 n4_1 1k
Rv3_1 n3_1 n3_2 1k
C3_1 n3_1 0 1n
D3_1 n3_1 0 DGRID
Rh4_1 n4_1 n5_1 1k
Rv4_1 n4_1 n4_2 1k
C4_1 n4_1 0 1n
D4_1 n4_1 0 DGRID
Rh5_1 n5_1 n6_1 1k
Rv5_1 n5_1 n5_2 1k
C5_1 n5_1 0 1n
D5_1 n5_1 0 DGRID
Rh6_1 n6_1 n7_1 1k
Rv6_1 n6_1 n6_2 1k
C6_1 n6_1 0 1n
D6_1 n6_1 0 DGRID
Rv7_1 n7_1 n7_2 1k
C7_1 n7_1 0 1n
D7_1 n7_1 0 DGRID
Rh0_2 n0_2 n1_2 1k
Rv0_2 n0_2 n0_3 1k
C0_2 n0_2 0 1n
D0_2 n0_2 0 DGRID
Rh1_2 n1_2 n2_2 1k
Rv1_2 n1_2 n1_3 1k
C1_2 n1_2 0 1n
D1_2 n1_2 0 DGRID
Rh2_2 n2_2 n3_2 1k
Rv2_2 n2_2 n2_3 1k
C2_2 n2_2 0 1n
D2_2 n2_2 0 DGRID
Rh3_2 n3_2 n4_2 1k
Rv3_2 n3_2 n3_3 1k
C3_2 n3_2 0 1n
D3_2 n3_2 0 DGRID
Rh4_2 n4_2 n5_2 1k
Rv4_2 n4_2 n4_3 1k
C4_2 n4_2 0 1n
D4_2 n4_2 0 DGRID
Rh5_2 n5_2 n6_2 1k
Rv5_2 n5_2 n5_3 1k
C5_2 n5_2 0 1n
D5_2 n5_2 0 DGRID
Rh6_2 n6_2 n7_2 1k
Rv6_2 n6_2 n6_3 1k
C6_2 n6_2 0 1n
D6_2 n6_2 0 DGRID
Rv7_2 n7_2 n7_3 1k
C7_2 n7_2 0 1n
D7_2 n7_2 0 DGRID
Rh0_3 n0_3 n1_3 1k
Rv0_3 n0_3 n0_4 1k
C0_3 n0_3 0 1n
D0_3 n0_3 0 DGRID
Rh1_3 n1_3 n2_3 1k
Rv1_3 n1_3 n1_4 1k
C1_3 n1_3 0 1n
D1_3 n1_3 0 DGRID
Rh2_3 n2_3 n3_3 1k
Rv2_3 n2_3 n2_4 1k
C2_3 n2_3 0 1n
D2_3 n2_3 0 DGRID
Rh3_3 n3_3 n4_3 1k
Rv3_3 n3_3 n3_4 1k
C3_3 n3_3 0 1n
D3_3 n3_3 0 DGRID
Rh4_3 n4_3 n5_3 1k
Rv4_3 n4_3 out 1k
C4_3 n4_3 0 1n
D4_3 n4_3 0 DGRID
Rh5_3 n5_3 n6_3 1k
Rv5_3 n5_3 n5_4 1k
C5_3 n5_3 0 1n
D5_3 n5_3 0 DGRID
Rh6_3 n6_3 n7_3 1k
Rv6_3 n6_3 n6_4 1k
C6_3 n6_3 0 1n
D6_3 n6_3 0 DGRID
Rv7_3 n7_3 n7_4 1k
C7_3 n7_3 0 1n
D7_3 n7_3 0 DGRID
Rh0_4 n0_4 n1_4 1k
Rv0_4 n0_4 n0_5 1k
C0_4 n0_4 0 1n
D0_4 n0_4 0 DGRID
Rh1_4 n1_4 n2_4 1k
Rv1_4 n1_4 n1_5 1k
C1_4 n1_4 0 1n
D1_4 n1_4 0 DGRID
Rh2_4 n2_4 n3_4 1k
Rv2_4 n2_4 n2_5 1k
C2_4 n2_4 0 1n
D2_4 n2_4 0 DGRID
Rh3_4 n3_4 out 1k
Rv3_4 n3_4 n3_5 1k
C3_4 n3_4 0 1n
D3_4 n3_4 0 DGRID
Rh4_4 out n5_4 1k
Rv4_4 out n4_5 1k
C4_4 out 0 1n
D4_4 out 0 DGRID
Rh5_4 n5_4 n6_4 1k
Rv5_4 n5_4 n5_5 1k
C5_4 n5_4 0 1n
D5_4 n5_4 0 DGRID
Rh6_4 n6_4 n7_4 1k
Rv6_4 n6_4 n6_5 1k
C6_4 n6_4 0 1n
D6_4 n6_4 0 DGRID
Rv7_4 n7_4 n7_5 1k
C7_4 n7_4 0 1n
D7_4 n7_4 0 DGRID
Rh0_5 n0_5 n1_5 1k
Rv0_5 n0_5 n0_6 1k
C0_5 n0_5 0 1n
D0_5 n0_5 0 DGRID
Rh1_5 n1_5 n2_5 1k
Rv1_5 n1_5 n1_6 1k
C1_5 n1_5 0 1n
D1_5 n1_5 0 DGRID
Rh2_5 n2_5 n3_5 1k
Rv2_5 n2_5 n2_6 1k
C2_5 n2_5 0 1n
D2_5 n2_5 0 DGRID
Rh3_5 n3_5 n4_5 1k
Rv3_5 n3_5 n3_6 1k
C3_5 n3_5 0 1n
D3_5 n3_5 0 DGRID
Rh4_5 n4_5 n5_5 1k
Rv4_5 n4_5 n4_6 1k
C4_5 n4_5 0 1n
D4_5 n4_5 0 DGRID
Rh5_5 n5_5 n6_5 1k
Rv5_5 n5_5 n5_6 1k
C5_5 n5_5 0 1n
D5_5 n5_5 0 DGRID
Rh6_5 n6_5 n7_5 1k
Rv6_5 n6_5 n6_6 1k
C6_5 n6_5 0 1n
D6_5 n6_5 0 DGRID
Rv7_5 n7_5 n7_6 1k
C7_5 n7_5 0 1n
D7_5 n7_5 0 DGRID
Rh0_6 n0_6 n1_6 1k
Rv0_6 n0_6 n0_7 1k
C0_6 n0_6 0 1n
D0_6 n0_6 0 DGRID
Rh1_6 n1_6 n2_6 1k
Rv1_6 n1_6 n1_7 1k
C1_6 n1_6 0 1n
D1_6 n1_6 0 DGRID
Rh2_6 n2_6 n3_6 1k
Rv2_6 n2_6 n2_7 1k
C2_6 n2_6 0 1n
D2_6 n2_6 0 DGRID
Rh3_6 n3_6 n4_6 1k
Rv3_6 n3_6 n3_7 1k
C3_6 n3_6 0 1n
D3_6 n3_6 0 DGRID
Rh4_6 n4_6 n5_6 1k
Rv4_6 n4_6 n4_7 1k
C4_6 n4_6 0 1n
D4_6 n4_6 0 DGRID
Rh5_6 n5_6 n6_6 1k
Rv5_6 n5_6 n5_7 1k
C5_6 n5_6 0 1n
D5_6 n5_6 0 DGRID
Rh6_6 n6_6 n7_6 1k
Rv6_6 n6_6 n6_7 1k
C6_6 n6_6 0 1n
D6_6 n6_6 0 DGRID
Rv7_6 n7_6 n7_7 1k
C7_6 n7_6 0 1n
D7_6 n7_6 0 DGRID
Rh0_7 n0_7 n1_7 1k
C0_7 n0_7 0 1n
D0_7 n0_7 0 DGRID
Rh1_7 n1_7 n2_7 1k
C1_7 n1_7 0 1n
D1_7 n1_7 0 DGRID
Rh2_7 n2_7 n3_7 1k
C2_7 n2_7 0 1n
D2_7 n2_7 0 DGRID
Rh3_7 n3_7 n4_7 1k
C3_7 n3_7 0 1n
D3_7 n3_7 0 DGRID
Rh4_7 n4_7 n5_7 1k
C4_7 n4_7 0 1n
D4_7 n4_7 0 DGRID
Rh5_7 n5_7 n6_7 1k
C5_7 n5_7 0 1n
D5_7 n5_7 0 DGRID
Rh6_7 n6_7 n7_7 1k
C6_7 n6_7 0 1n
D6_7 n6_7 0 DGRID
C7_7 n7_7 0 1n
D7_7 n7_7 0 DGRID
Rreturn n7_7 0 1k
.op
.end
