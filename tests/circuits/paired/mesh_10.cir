* 2D resistor mesh 10x10
Vin n0_0 0 DC 1
R0 n0_0 n1_0 1k
R1 n0_0 n0_1 1k
R2 n1_0 n2_0 1k
R3 n1_0 n1_1 1k
R4 n2_0 n3_0 1k
R5 n2_0 n2_1 1k
R6 n3_0 n4_0 1k
R7 n3_0 n3_1 1k
R8 n4_0 n5_0 1k
R9 n4_0 n4_1 1k
R10 n5_0 n6_0 1k
R11 n5_0 n5_1 1k
R12 n6_0 n7_0 1k
R13 n6_0 n6_1 1k
R14 n7_0 n8_0 1k
R15 n7_0 n7_1 1k
R16 n8_0 n9_0 1k
R17 n8_0 n8_1 1k
R18 n9_0 n9_1 1k
R19 n0_1 n1_1 1k
R20 n0_1 n0_2 1k
R21 n1_1 n2_1 1k
R22 n1_1 n1_2 1k
R23 n2_1 n3_1 1k
R24 n2_1 n2_2 1k
R25 n3_1 n4_1 1k
R26 n3_1 n3_2 1k
R27 n4_1 n5_1 1k
R28 n4_1 n4_2 1k
R29 n5_1 n6_1 1k
R30 n5_1 n5_2 1k
R31 n6_1 n7_1 1k
R32 n6_1 n6_2 1k
R33 n7_1 n8_1 1k
R34 n7_1 n7_2 1k
R35 n8_1 n9_1 1k
R36 n8_1 n8_2 1k
R37 n9_1 n9_2 1k
R38 n0_2 n1_2 1k
R39 n0_2 n0_3 1k
R40 n1_2 n2_2 1k
R41 n1_2 n1_3 1k
R42 n2_2 n3_2 1k
R43 n2_2 n2_3 1k
R44 n3_2 n4_2 1k
R45 n3_2 n3_3 1k
R46 n4_2 n5_2 1k
R47 n4_2 n4_3 1k
R48 n5_2 n6_2 1k
R49 n5_2 n5_3 1k
R50 n6_2 n7_2 1k
R51 n6_2 n6_3 1k
R52 n7_2 n8_2 1k
R53 n7_2 n7_3 1k
R54 n8_2 n9_2 1k
R55 n8_2 n8_3 1k
R56 n9_2 n9_3 1k
R57 n0_3 n1_3 1k
R58 n0_3 n0_4 1k
R59 n1_3 n2_3 1k
R60 n1_3 n1_4 1k
R61 n2_3 n3_3 1k
R62 n2_3 n2_4 1k
R63 n3_3 n4_3 1k
R64 n3_3 n3_4 1k
R65 n4_3 n5_3 1k
R66 n4_3 n4_4 1k
R67 n5_3 n6_3 1k
R68 n5_3 n5_4 1k
R69 n6_3 n7_3 1k
R70 n6_3 n6_4 1k
R71 n7_3 n8_3 1k
R72 n7_3 n7_4 1k
R73 n8_3 n9_3 1k
R74 n8_3 n8_4 1k
R75 n9_3 n9_4 1k
R76 n0_4 n1_4 1k
R77 n0_4 n0_5 1k
R78 n1_4 n2_4 1k
R79 n1_4 n1_5 1k
R80 n2_4 n3_4 1k
R81 n2_4 n2_5 1k
R82 n3_4 n4_4 1k
R83 n3_4 n3_5 1k
R84 n4_4 n5_4 1k
R85 n4_4 n4_5 1k
R86 n5_4 n6_4 1k
R87 n5_4 n5_5 1k
R88 n6_4 n7_4 1k
R89 n6_4 n6_5 1k
R90 n7_4 n8_4 1k
R91 n7_4 n7_5 1k
R92 n8_4 n9_4 1k
R93 n8_4 n8_5 1k
R94 n9_4 n9_5 1k
R95 n0_5 n1_5 1k
R96 n0_5 n0_6 1k
R97 n1_5 n2_5 1k
R98 n1_5 n1_6 1k
R99 n2_5 n3_5 1k
R100 n2_5 n2_6 1k
R101 n3_5 n4_5 1k
R102 n3_5 n3_6 1k
R103 n4_5 n5_5 1k
R104 n4_5 n4_6 1k
R105 n5_5 n6_5 1k
R106 n5_5 n5_6 1k
R107 n6_5 n7_5 1k
R108 n6_5 n6_6 1k
R109 n7_5 n8_5 1k
R110 n7_5 n7_6 1k
R111 n8_5 n9_5 1k
R112 n8_5 n8_6 1k
R113 n9_5 n9_6 1k
R114 n0_6 n1_6 1k
R115 n0_6 n0_7 1k
R116 n1_6 n2_6 1k
R117 n1_6 n1_7 1k
R118 n2_6 n3_6 1k
R119 n2_6 n2_7 1k
R120 n3_6 n4_6 1k
R121 n3_6 n3_7 1k
R122 n4_6 n5_6 1k
R123 n4_6 n4_7 1k
R124 n5_6 n6_6 1k
R125 n5_6 n5_7 1k
R126 n6_6 n7_6 1k
R127 n6_6 n6_7 1k
R128 n7_6 n8_6 1k
R129 n7_6 n7_7 1k
R130 n8_6 n9_6 1k
R131 n8_6 n8_7 1k
R132 n9_6 n9_7 1k
R133 n0_7 n1_7 1k
R134 n0_7 n0_8 1k
R135 n1_7 n2_7 1k
R136 n1_7 n1_8 1k
R137 n2_7 n3_7 1k
R138 n2_7 n2_8 1k
R139 n3_7 n4_7 1k
R140 n3_7 n3_8 1k
R141 n4_7 n5_7 1k
R142 n4_7 n4_8 1k
R143 n5_7 n6_7 1k
R144 n5_7 n5_8 1k
R145 n6_7 n7_7 1k
R146 n6_7 n6_8 1k
R147 n7_7 n8_7 1k
R148 n7_7 n7_8 1k
R149 n8_7 n9_7 1k
R150 n8_7 n8_8 1k
R151 n9_7 n9_8 1k
R152 n0_8 n1_8 1k
R153 n0_8 n0_9 1k
R154 n1_8 n2_8 1k
R155 n1_8 n1_9 1k
R156 n2_8 n3_8 1k
R157 n2_8 n2_9 1k
R158 n3_8 n4_8 1k
R159 n3_8 n3_9 1k
R160 n4_8 n5_8 1k
R161 n4_8 n4_9 1k
R162 n5_8 n6_8 1k
R163 n5_8 n5_9 1k
R164 n6_8 n7_8 1k
R165 n6_8 n6_9 1k
R166 n7_8 n8_8 1k
R167 n7_8 n7_9 1k
R168 n8_8 n9_8 1k
R169 n8_8 n8_9 1k
R170 n9_8 0 1k
R171 n0_9 n1_9 1k
R172 n1_9 n2_9 1k
R173 n2_9 n3_9 1k
R174 n3_9 n4_9 1k
R175 n4_9 n5_9 1k
R176 n5_9 n6_9 1k
R177 n6_9 n7_9 1k
R178 n7_9 n8_9 1k
R179 n8_9 0 1k
.op
.end
