* synthetic diode_rc grid 24x24
V1 in 0 DC 0.8 AC 1 PULSE(0.2 0.8 0 10u 10u 50u 100u)
Rfeed in n0_0 1k
.model DGRID D(IS=1e-12 N=1.2 RS=2 CJO=1p M=0.4 TT=1n)
Rh0_0 n0_0 n1_0 1k
Rv0_0 n0_0 n0_1 1k
C0_0 n0_0 0 1n
D0_0 n0_0 0 DGRID
Rh1_0 n1_0 n2_0 1k
Rv1_0 n1_0 n1_1 1k
C1_0 n1_0 0 1n
D1_0 n1_0 0 DGRID
Rh2_0 n2_0 n3_0 1k
Rv2_0 n2_0 n2_1 1k
C2_0 n2_0 0 1n
D2_0 n2_0 0 DGRID
Rh3_0 n3_0 n4_0 1k
Rv3_0 n3_0 n3_1 1k
C3_0 n3_0 0 1n
D3_0 n3_0 0 DGRID
Rh4_0 n4_0 n5_0 1k
Rv4_0 n4_0 n4_1 1k
C4_0 n4_0 0 1n
D4_0 n4_0 0 DGRID
Rh5_0 n5_0 n6_0 1k
Rv5_0 n5_0 n5_1 1k
C5_0 n5_0 0 1n
D5_0 n5_0 0 DGRID
Rh6_0 n6_0 n7_0 1k
Rv6_0 n6_0 n6_1 1k
C6_0 n6_0 0 1n
D6_0 n6_0 0 DGRID
Rh7_0 n7_0 n8_0 1k
Rv7_0 n7_0 n7_1 1k
C7_0 n7_0 0 1n
D7_0 n7_0 0 DGRID
Rh8_0 n8_0 n9_0 1k
Rv8_0 n8_0 n8_1 1k
C8_0 n8_0 0 1n
D8_0 n8_0 0 DGRID
Rh9_0 n9_0 n10_0 1k
Rv9_0 n9_0 n9_1 1k
C9_0 n9_0 0 1n
D9_0 n9_0 0 DGRID
Rh10_0 n10_0 n11_0 1k
Rv10_0 n10_0 n10_1 1k
C10_0 n10_0 0 1n
D10_0 n10_0 0 DGRID
Rh11_0 n11_0 n12_0 1k
Rv11_0 n11_0 n11_1 1k
C11_0 n11_0 0 1n
D11_0 n11_0 0 DGRID
Rh12_0 n12_0 n13_0 1k
Rv12_0 n12_0 n12_1 1k
C12_0 n12_0 0 1n
D12_0 n12_0 0 DGRID
Rh13_0 n13_0 n14_0 1k
Rv13_0 n13_0 n13_1 1k
C13_0 n13_0 0 1n
D13_0 n13_0 0 DGRID
Rh14_0 n14_0 n15_0 1k
Rv14_0 n14_0 n14_1 1k
C14_0 n14_0 0 1n
D14_0 n14_0 0 DGRID
Rh15_0 n15_0 n16_0 1k
Rv15_0 n15_0 n15_1 1k
C15_0 n15_0 0 1n
D15_0 n15_0 0 DGRID
Rh16_0 n16_0 n17_0 1k
Rv16_0 n16_0 n16_1 1k
C16_0 n16_0 0 1n
D16_0 n16_0 0 DGRID
Rh17_0 n17_0 n18_0 1k
Rv17_0 n17_0 n17_1 1k
C17_0 n17_0 0 1n
D17_0 n17_0 0 DGRID
Rh18_0 n18_0 n19_0 1k
Rv18_0 n18_0 n18_1 1k
C18_0 n18_0 0 1n
D18_0 n18_0 0 DGRID
Rh19_0 n19_0 n20_0 1k
Rv19_0 n19_0 n19_1 1k
C19_0 n19_0 0 1n
D19_0 n19_0 0 DGRID
Rh20_0 n20_0 n21_0 1k
Rv20_0 n20_0 n20_1 1k
C20_0 n20_0 0 1n
D20_0 n20_0 0 DGRID
Rh21_0 n21_0 n22_0 1k
Rv21_0 n21_0 n21_1 1k
C21_0 n21_0 0 1n
D21_0 n21_0 0 DGRID
Rh22_0 n22_0 n23_0 1k
Rv22_0 n22_0 n22_1 1k
C22_0 n22_0 0 1n
D22_0 n22_0 0 DGRID
Rv23_0 n23_0 n23_1 1k
C23_0 n23_0 0 1n
D23_0 n23_0 0 DGRID
Rh0_1 n0_1 n1_1 1k
Rv0_1 n0_1 n0_2 1k
C0_1 n0_1 0 1n
D0_1 n0_1 0 DGRID
Rh1_1 n1_1 n2_1 1k
Rv1_1 n1_1 n1_2 1k
C1_1 n1_1 0 1n
D1_1 n1_1 0 DGRID
Rh2_1 n2_1 n3_1 1k
Rv2_1 n2_1 n2_2 1k
C2_1 n2_1 0 1n
D2_1 n2_1 0 DGRID
Rh3_1 n3_1 n4_1 1k
Rv3_1 n3_1 n3_2 1k
C3_1 n3_1 0 1n
D3_1 n3_1 0 DGRID
Rh4_1 n4_1 n5_1 1k
Rv4_1 n4_1 n4_2 1k
C4_1 n4_1 0 1n
D4_1 n4_1 0 DGRID
Rh5_1 n5_1 n6_1 1k
Rv5_1 n5_1 n5_2 1k
C5_1 n5_1 0 1n
D5_1 n5_1 0 DGRID
Rh6_1 n6_1 n7_1 1k
Rv6_1 n6_1 n6_2 1k
C6_1 n6_1 0 1n
D6_1 n6_1 0 DGRID
Rh7_1 n7_1 n8_1 1k
Rv7_1 n7_1 n7_2 1k
C7_1 n7_1 0 1n
D7_1 n7_1 0 DGRID
Rh8_1 n8_1 n9_1 1k
Rv8_1 n8_1 n8_2 1k
C8_1 n8_1 0 1n
D8_1 n8_1 0 DGRID
Rh9_1 n9_1 n10_1 1k
Rv9_1 n9_1 n9_2 1k
C9_1 n9_1 0 1n
D9_1 n9_1 0 DGRID
Rh10_1 n10_1 n11_1 1k
Rv10_1 n10_1 n10_2 1k
C10_1 n10_1 0 1n
D10_1 n10_1 0 DGRID
Rh11_1 n11_1 n12_1 1k
Rv11_1 n11_1 n11_2 1k
C11_1 n11_1 0 1n
D11_1 n11_1 0 DGRID
Rh12_1 n12_1 n13_1 1k
Rv12_1 n12_1 n12_2 1k
C12_1 n12_1 0 1n
D12_1 n12_1 0 DGRID
Rh13_1 n13_1 n14_1 1k
Rv13_1 n13_1 n13_2 1k
C13_1 n13_1 0 1n
D13_1 n13_1 0 DGRID
Rh14_1 n14_1 n15_1 1k
Rv14_1 n14_1 n14_2 1k
C14_1 n14_1 0 1n
D14_1 n14_1 0 DGRID
Rh15_1 n15_1 n16_1 1k
Rv15_1 n15_1 n15_2 1k
C15_1 n15_1 0 1n
D15_1 n15_1 0 DGRID
Rh16_1 n16_1 n17_1 1k
Rv16_1 n16_1 n16_2 1k
C16_1 n16_1 0 1n
D16_1 n16_1 0 DGRID
Rh17_1 n17_1 n18_1 1k
Rv17_1 n17_1 n17_2 1k
C17_1 n17_1 0 1n
D17_1 n17_1 0 DGRID
Rh18_1 n18_1 n19_1 1k
Rv18_1 n18_1 n18_2 1k
C18_1 n18_1 0 1n
D18_1 n18_1 0 DGRID
Rh19_1 n19_1 n20_1 1k
Rv19_1 n19_1 n19_2 1k
C19_1 n19_1 0 1n
D19_1 n19_1 0 DGRID
Rh20_1 n20_1 n21_1 1k
Rv20_1 n20_1 n20_2 1k
C20_1 n20_1 0 1n
D20_1 n20_1 0 DGRID
Rh21_1 n21_1 n22_1 1k
Rv21_1 n21_1 n21_2 1k
C21_1 n21_1 0 1n
D21_1 n21_1 0 DGRID
Rh22_1 n22_1 n23_1 1k
Rv22_1 n22_1 n22_2 1k
C22_1 n22_1 0 1n
D22_1 n22_1 0 DGRID
Rv23_1 n23_1 n23_2 1k
C23_1 n23_1 0 1n
D23_1 n23_1 0 DGRID
Rh0_2 n0_2 n1_2 1k
Rv0_2 n0_2 n0_3 1k
C0_2 n0_2 0 1n
D0_2 n0_2 0 DGRID
Rh1_2 n1_2 n2_2 1k
Rv1_2 n1_2 n1_3 1k
C1_2 n1_2 0 1n
D1_2 n1_2 0 DGRID
Rh2_2 n2_2 n3_2 1k
Rv2_2 n2_2 n2_3 1k
C2_2 n2_2 0 1n
D2_2 n2_2 0 DGRID
Rh3_2 n3_2 n4_2 1k
Rv3_2 n3_2 n3_3 1k
C3_2 n3_2 0 1n
D3_2 n3_2 0 DGRID
Rh4_2 n4_2 n5_2 1k
Rv4_2 n4_2 n4_3 1k
C4_2 n4_2 0 1n
D4_2 n4_2 0 DGRID
Rh5_2 n5_2 n6_2 1k
Rv5_2 n5_2 n5_3 1k
C5_2 n5_2 0 1n
D5_2 n5_2 0 DGRID
Rh6_2 n6_2 n7_2 1k
Rv6_2 n6_2 n6_3 1k
C6_2 n6_2 0 1n
D6_2 n6_2 0 DGRID
Rh7_2 n7_2 n8_2 1k
Rv7_2 n7_2 n7_3 1k
C7_2 n7_2 0 1n
D7_2 n7_2 0 DGRID
Rh8_2 n8_2 n9_2 1k
Rv8_2 n8_2 n8_3 1k
C8_2 n8_2 0 1n
D8_2 n8_2 0 DGRID
Rh9_2 n9_2 n10_2 1k
Rv9_2 n9_2 n9_3 1k
C9_2 n9_2 0 1n
D9_2 n9_2 0 DGRID
Rh10_2 n10_2 n11_2 1k
Rv10_2 n10_2 n10_3 1k
C10_2 n10_2 0 1n
D10_2 n10_2 0 DGRID
Rh11_2 n11_2 n12_2 1k
Rv11_2 n11_2 n11_3 1k
C11_2 n11_2 0 1n
D11_2 n11_2 0 DGRID
Rh12_2 n12_2 n13_2 1k
Rv12_2 n12_2 n12_3 1k
C12_2 n12_2 0 1n
D12_2 n12_2 0 DGRID
Rh13_2 n13_2 n14_2 1k
Rv13_2 n13_2 n13_3 1k
C13_2 n13_2 0 1n
D13_2 n13_2 0 DGRID
Rh14_2 n14_2 n15_2 1k
Rv14_2 n14_2 n14_3 1k
C14_2 n14_2 0 1n
D14_2 n14_2 0 DGRID
Rh15_2 n15_2 n16_2 1k
Rv15_2 n15_2 n15_3 1k
C15_2 n15_2 0 1n
D15_2 n15_2 0 DGRID
Rh16_2 n16_2 n17_2 1k
Rv16_2 n16_2 n16_3 1k
C16_2 n16_2 0 1n
D16_2 n16_2 0 DGRID
Rh17_2 n17_2 n18_2 1k
Rv17_2 n17_2 n17_3 1k
C17_2 n17_2 0 1n
D17_2 n17_2 0 DGRID
Rh18_2 n18_2 n19_2 1k
Rv18_2 n18_2 n18_3 1k
C18_2 n18_2 0 1n
D18_2 n18_2 0 DGRID
Rh19_2 n19_2 n20_2 1k
Rv19_2 n19_2 n19_3 1k
C19_2 n19_2 0 1n
D19_2 n19_2 0 DGRID
Rh20_2 n20_2 n21_2 1k
Rv20_2 n20_2 n20_3 1k
C20_2 n20_2 0 1n
D20_2 n20_2 0 DGRID
Rh21_2 n21_2 n22_2 1k
Rv21_2 n21_2 n21_3 1k
C21_2 n21_2 0 1n
D21_2 n21_2 0 DGRID
Rh22_2 n22_2 n23_2 1k
Rv22_2 n22_2 n22_3 1k
C22_2 n22_2 0 1n
D22_2 n22_2 0 DGRID
Rv23_2 n23_2 n23_3 1k
C23_2 n23_2 0 1n
D23_2 n23_2 0 DGRID
Rh0_3 n0_3 n1_3 1k
Rv0_3 n0_3 n0_4 1k
C0_3 n0_3 0 1n
D0_3 n0_3 0 DGRID
Rh1_3 n1_3 n2_3 1k
Rv1_3 n1_3 n1_4 1k
C1_3 n1_3 0 1n
D1_3 n1_3 0 DGRID
Rh2_3 n2_3 n3_3 1k
Rv2_3 n2_3 n2_4 1k
C2_3 n2_3 0 1n
D2_3 n2_3 0 DGRID
Rh3_3 n3_3 n4_3 1k
Rv3_3 n3_3 n3_4 1k
C3_3 n3_3 0 1n
D3_3 n3_3 0 DGRID
Rh4_3 n4_3 n5_3 1k
Rv4_3 n4_3 n4_4 1k
C4_3 n4_3 0 1n
D4_3 n4_3 0 DGRID
Rh5_3 n5_3 n6_3 1k
Rv5_3 n5_3 n5_4 1k
C5_3 n5_3 0 1n
D5_3 n5_3 0 DGRID
Rh6_3 n6_3 n7_3 1k
Rv6_3 n6_3 n6_4 1k
C6_3 n6_3 0 1n
D6_3 n6_3 0 DGRID
Rh7_3 n7_3 n8_3 1k
Rv7_3 n7_3 n7_4 1k
C7_3 n7_3 0 1n
D7_3 n7_3 0 DGRID
Rh8_3 n8_3 n9_3 1k
Rv8_3 n8_3 n8_4 1k
C8_3 n8_3 0 1n
D8_3 n8_3 0 DGRID
Rh9_3 n9_3 n10_3 1k
Rv9_3 n9_3 n9_4 1k
C9_3 n9_3 0 1n
D9_3 n9_3 0 DGRID
Rh10_3 n10_3 n11_3 1k
Rv10_3 n10_3 n10_4 1k
C10_3 n10_3 0 1n
D10_3 n10_3 0 DGRID
Rh11_3 n11_3 n12_3 1k
Rv11_3 n11_3 n11_4 1k
C11_3 n11_3 0 1n
D11_3 n11_3 0 DGRID
Rh12_3 n12_3 n13_3 1k
Rv12_3 n12_3 n12_4 1k
C12_3 n12_3 0 1n
D12_3 n12_3 0 DGRID
Rh13_3 n13_3 n14_3 1k
Rv13_3 n13_3 n13_4 1k
C13_3 n13_3 0 1n
D13_3 n13_3 0 DGRID
Rh14_3 n14_3 n15_3 1k
Rv14_3 n14_3 n14_4 1k
C14_3 n14_3 0 1n
D14_3 n14_3 0 DGRID
Rh15_3 n15_3 n16_3 1k
Rv15_3 n15_3 n15_4 1k
C15_3 n15_3 0 1n
D15_3 n15_3 0 DGRID
Rh16_3 n16_3 n17_3 1k
Rv16_3 n16_3 n16_4 1k
C16_3 n16_3 0 1n
D16_3 n16_3 0 DGRID
Rh17_3 n17_3 n18_3 1k
Rv17_3 n17_3 n17_4 1k
C17_3 n17_3 0 1n
D17_3 n17_3 0 DGRID
Rh18_3 n18_3 n19_3 1k
Rv18_3 n18_3 n18_4 1k
C18_3 n18_3 0 1n
D18_3 n18_3 0 DGRID
Rh19_3 n19_3 n20_3 1k
Rv19_3 n19_3 n19_4 1k
C19_3 n19_3 0 1n
D19_3 n19_3 0 DGRID
Rh20_3 n20_3 n21_3 1k
Rv20_3 n20_3 n20_4 1k
C20_3 n20_3 0 1n
D20_3 n20_3 0 DGRID
Rh21_3 n21_3 n22_3 1k
Rv21_3 n21_3 n21_4 1k
C21_3 n21_3 0 1n
D21_3 n21_3 0 DGRID
Rh22_3 n22_3 n23_3 1k
Rv22_3 n22_3 n22_4 1k
C22_3 n22_3 0 1n
D22_3 n22_3 0 DGRID
Rv23_3 n23_3 n23_4 1k
C23_3 n23_3 0 1n
D23_3 n23_3 0 DGRID
Rh0_4 n0_4 n1_4 1k
Rv0_4 n0_4 n0_5 1k
C0_4 n0_4 0 1n
D0_4 n0_4 0 DGRID
Rh1_4 n1_4 n2_4 1k
Rv1_4 n1_4 n1_5 1k
C1_4 n1_4 0 1n
D1_4 n1_4 0 DGRID
Rh2_4 n2_4 n3_4 1k
Rv2_4 n2_4 n2_5 1k
C2_4 n2_4 0 1n
D2_4 n2_4 0 DGRID
Rh3_4 n3_4 n4_4 1k
Rv3_4 n3_4 n3_5 1k
C3_4 n3_4 0 1n
D3_4 n3_4 0 DGRID
Rh4_4 n4_4 n5_4 1k
Rv4_4 n4_4 n4_5 1k
C4_4 n4_4 0 1n
D4_4 n4_4 0 DGRID
Rh5_4 n5_4 n6_4 1k
Rv5_4 n5_4 n5_5 1k
C5_4 n5_4 0 1n
D5_4 n5_4 0 DGRID
Rh6_4 n6_4 n7_4 1k
Rv6_4 n6_4 n6_5 1k
C6_4 n6_4 0 1n
D6_4 n6_4 0 DGRID
Rh7_4 n7_4 n8_4 1k
Rv7_4 n7_4 n7_5 1k
C7_4 n7_4 0 1n
D7_4 n7_4 0 DGRID
Rh8_4 n8_4 n9_4 1k
Rv8_4 n8_4 n8_5 1k
C8_4 n8_4 0 1n
D8_4 n8_4 0 DGRID
Rh9_4 n9_4 n10_4 1k
Rv9_4 n9_4 n9_5 1k
C9_4 n9_4 0 1n
D9_4 n9_4 0 DGRID
Rh10_4 n10_4 n11_4 1k
Rv10_4 n10_4 n10_5 1k
C10_4 n10_4 0 1n
D10_4 n10_4 0 DGRID
Rh11_4 n11_4 n12_4 1k
Rv11_4 n11_4 n11_5 1k
C11_4 n11_4 0 1n
D11_4 n11_4 0 DGRID
Rh12_4 n12_4 n13_4 1k
Rv12_4 n12_4 n12_5 1k
C12_4 n12_4 0 1n
D12_4 n12_4 0 DGRID
Rh13_4 n13_4 n14_4 1k
Rv13_4 n13_4 n13_5 1k
C13_4 n13_4 0 1n
D13_4 n13_4 0 DGRID
Rh14_4 n14_4 n15_4 1k
Rv14_4 n14_4 n14_5 1k
C14_4 n14_4 0 1n
D14_4 n14_4 0 DGRID
Rh15_4 n15_4 n16_4 1k
Rv15_4 n15_4 n15_5 1k
C15_4 n15_4 0 1n
D15_4 n15_4 0 DGRID
Rh16_4 n16_4 n17_4 1k
Rv16_4 n16_4 n16_5 1k
C16_4 n16_4 0 1n
D16_4 n16_4 0 DGRID
Rh17_4 n17_4 n18_4 1k
Rv17_4 n17_4 n17_5 1k
C17_4 n17_4 0 1n
D17_4 n17_4 0 DGRID
Rh18_4 n18_4 n19_4 1k
Rv18_4 n18_4 n18_5 1k
C18_4 n18_4 0 1n
D18_4 n18_4 0 DGRID
Rh19_4 n19_4 n20_4 1k
Rv19_4 n19_4 n19_5 1k
C19_4 n19_4 0 1n
D19_4 n19_4 0 DGRID
Rh20_4 n20_4 n21_4 1k
Rv20_4 n20_4 n20_5 1k
C20_4 n20_4 0 1n
D20_4 n20_4 0 DGRID
Rh21_4 n21_4 n22_4 1k
Rv21_4 n21_4 n21_5 1k
C21_4 n21_4 0 1n
D21_4 n21_4 0 DGRID
Rh22_4 n22_4 n23_4 1k
Rv22_4 n22_4 n22_5 1k
C22_4 n22_4 0 1n
D22_4 n22_4 0 DGRID
Rv23_4 n23_4 n23_5 1k
C23_4 n23_4 0 1n
D23_4 n23_4 0 DGRID
Rh0_5 n0_5 n1_5 1k
Rv0_5 n0_5 n0_6 1k
C0_5 n0_5 0 1n
D0_5 n0_5 0 DGRID
Rh1_5 n1_5 n2_5 1k
Rv1_5 n1_5 n1_6 1k
C1_5 n1_5 0 1n
D1_5 n1_5 0 DGRID
Rh2_5 n2_5 n3_5 1k
Rv2_5 n2_5 n2_6 1k
C2_5 n2_5 0 1n
D2_5 n2_5 0 DGRID
Rh3_5 n3_5 n4_5 1k
Rv3_5 n3_5 n3_6 1k
C3_5 n3_5 0 1n
D3_5 n3_5 0 DGRID
Rh4_5 n4_5 n5_5 1k
Rv4_5 n4_5 n4_6 1k
C4_5 n4_5 0 1n
D4_5 n4_5 0 DGRID
Rh5_5 n5_5 n6_5 1k
Rv5_5 n5_5 n5_6 1k
C5_5 n5_5 0 1n
D5_5 n5_5 0 DGRID
Rh6_5 n6_5 n7_5 1k
Rv6_5 n6_5 n6_6 1k
C6_5 n6_5 0 1n
D6_5 n6_5 0 DGRID
Rh7_5 n7_5 n8_5 1k
Rv7_5 n7_5 n7_6 1k
C7_5 n7_5 0 1n
D7_5 n7_5 0 DGRID
Rh8_5 n8_5 n9_5 1k
Rv8_5 n8_5 n8_6 1k
C8_5 n8_5 0 1n
D8_5 n8_5 0 DGRID
Rh9_5 n9_5 n10_5 1k
Rv9_5 n9_5 n9_6 1k
C9_5 n9_5 0 1n
D9_5 n9_5 0 DGRID
Rh10_5 n10_5 n11_5 1k
Rv10_5 n10_5 n10_6 1k
C10_5 n10_5 0 1n
D10_5 n10_5 0 DGRID
Rh11_5 n11_5 n12_5 1k
Rv11_5 n11_5 n11_6 1k
C11_5 n11_5 0 1n
D11_5 n11_5 0 DGRID
Rh12_5 n12_5 n13_5 1k
Rv12_5 n12_5 n12_6 1k
C12_5 n12_5 0 1n
D12_5 n12_5 0 DGRID
Rh13_5 n13_5 n14_5 1k
Rv13_5 n13_5 n13_6 1k
C13_5 n13_5 0 1n
D13_5 n13_5 0 DGRID
Rh14_5 n14_5 n15_5 1k
Rv14_5 n14_5 n14_6 1k
C14_5 n14_5 0 1n
D14_5 n14_5 0 DGRID
Rh15_5 n15_5 n16_5 1k
Rv15_5 n15_5 n15_6 1k
C15_5 n15_5 0 1n
D15_5 n15_5 0 DGRID
Rh16_5 n16_5 n17_5 1k
Rv16_5 n16_5 n16_6 1k
C16_5 n16_5 0 1n
D16_5 n16_5 0 DGRID
Rh17_5 n17_5 n18_5 1k
Rv17_5 n17_5 n17_6 1k
C17_5 n17_5 0 1n
D17_5 n17_5 0 DGRID
Rh18_5 n18_5 n19_5 1k
Rv18_5 n18_5 n18_6 1k
C18_5 n18_5 0 1n
D18_5 n18_5 0 DGRID
Rh19_5 n19_5 n20_5 1k
Rv19_5 n19_5 n19_6 1k
C19_5 n19_5 0 1n
D19_5 n19_5 0 DGRID
Rh20_5 n20_5 n21_5 1k
Rv20_5 n20_5 n20_6 1k
C20_5 n20_5 0 1n
D20_5 n20_5 0 DGRID
Rh21_5 n21_5 n22_5 1k
Rv21_5 n21_5 n21_6 1k
C21_5 n21_5 0 1n
D21_5 n21_5 0 DGRID
Rh22_5 n22_5 n23_5 1k
Rv22_5 n22_5 n22_6 1k
C22_5 n22_5 0 1n
D22_5 n22_5 0 DGRID
Rv23_5 n23_5 n23_6 1k
C23_5 n23_5 0 1n
D23_5 n23_5 0 DGRID
Rh0_6 n0_6 n1_6 1k
Rv0_6 n0_6 n0_7 1k
C0_6 n0_6 0 1n
D0_6 n0_6 0 DGRID
Rh1_6 n1_6 n2_6 1k
Rv1_6 n1_6 n1_7 1k
C1_6 n1_6 0 1n
D1_6 n1_6 0 DGRID
Rh2_6 n2_6 n3_6 1k
Rv2_6 n2_6 n2_7 1k
C2_6 n2_6 0 1n
D2_6 n2_6 0 DGRID
Rh3_6 n3_6 n4_6 1k
Rv3_6 n3_6 n3_7 1k
C3_6 n3_6 0 1n
D3_6 n3_6 0 DGRID
Rh4_6 n4_6 n5_6 1k
Rv4_6 n4_6 n4_7 1k
C4_6 n4_6 0 1n
D4_6 n4_6 0 DGRID
Rh5_6 n5_6 n6_6 1k
Rv5_6 n5_6 n5_7 1k
C5_6 n5_6 0 1n
D5_6 n5_6 0 DGRID
Rh6_6 n6_6 n7_6 1k
Rv6_6 n6_6 n6_7 1k
C6_6 n6_6 0 1n
D6_6 n6_6 0 DGRID
Rh7_6 n7_6 n8_6 1k
Rv7_6 n7_6 n7_7 1k
C7_6 n7_6 0 1n
D7_6 n7_6 0 DGRID
Rh8_6 n8_6 n9_6 1k
Rv8_6 n8_6 n8_7 1k
C8_6 n8_6 0 1n
D8_6 n8_6 0 DGRID
Rh9_6 n9_6 n10_6 1k
Rv9_6 n9_6 n9_7 1k
C9_6 n9_6 0 1n
D9_6 n9_6 0 DGRID
Rh10_6 n10_6 n11_6 1k
Rv10_6 n10_6 n10_7 1k
C10_6 n10_6 0 1n
D10_6 n10_6 0 DGRID
Rh11_6 n11_6 n12_6 1k
Rv11_6 n11_6 n11_7 1k
C11_6 n11_6 0 1n
D11_6 n11_6 0 DGRID
Rh12_6 n12_6 n13_6 1k
Rv12_6 n12_6 n12_7 1k
C12_6 n12_6 0 1n
D12_6 n12_6 0 DGRID
Rh13_6 n13_6 n14_6 1k
Rv13_6 n13_6 n13_7 1k
C13_6 n13_6 0 1n
D13_6 n13_6 0 DGRID
Rh14_6 n14_6 n15_6 1k
Rv14_6 n14_6 n14_7 1k
C14_6 n14_6 0 1n
D14_6 n14_6 0 DGRID
Rh15_6 n15_6 n16_6 1k
Rv15_6 n15_6 n15_7 1k
C15_6 n15_6 0 1n
D15_6 n15_6 0 DGRID
Rh16_6 n16_6 n17_6 1k
Rv16_6 n16_6 n16_7 1k
C16_6 n16_6 0 1n
D16_6 n16_6 0 DGRID
Rh17_6 n17_6 n18_6 1k
Rv17_6 n17_6 n17_7 1k
C17_6 n17_6 0 1n
D17_6 n17_6 0 DGRID
Rh18_6 n18_6 n19_6 1k
Rv18_6 n18_6 n18_7 1k
C18_6 n18_6 0 1n
D18_6 n18_6 0 DGRID
Rh19_6 n19_6 n20_6 1k
Rv19_6 n19_6 n19_7 1k
C19_6 n19_6 0 1n
D19_6 n19_6 0 DGRID
Rh20_6 n20_6 n21_6 1k
Rv20_6 n20_6 n20_7 1k
C20_6 n20_6 0 1n
D20_6 n20_6 0 DGRID
Rh21_6 n21_6 n22_6 1k
Rv21_6 n21_6 n21_7 1k
C21_6 n21_6 0 1n
D21_6 n21_6 0 DGRID
Rh22_6 n22_6 n23_6 1k
Rv22_6 n22_6 n22_7 1k
C22_6 n22_6 0 1n
D22_6 n22_6 0 DGRID
Rv23_6 n23_6 n23_7 1k
C23_6 n23_6 0 1n
D23_6 n23_6 0 DGRID
Rh0_7 n0_7 n1_7 1k
Rv0_7 n0_7 n0_8 1k
C0_7 n0_7 0 1n
D0_7 n0_7 0 DGRID
Rh1_7 n1_7 n2_7 1k
Rv1_7 n1_7 n1_8 1k
C1_7 n1_7 0 1n
D1_7 n1_7 0 DGRID
Rh2_7 n2_7 n3_7 1k
Rv2_7 n2_7 n2_8 1k
C2_7 n2_7 0 1n
D2_7 n2_7 0 DGRID
Rh3_7 n3_7 n4_7 1k
Rv3_7 n3_7 n3_8 1k
C3_7 n3_7 0 1n
D3_7 n3_7 0 DGRID
Rh4_7 n4_7 n5_7 1k
Rv4_7 n4_7 n4_8 1k
C4_7 n4_7 0 1n
D4_7 n4_7 0 DGRID
Rh5_7 n5_7 n6_7 1k
Rv5_7 n5_7 n5_8 1k
C5_7 n5_7 0 1n
D5_7 n5_7 0 DGRID
Rh6_7 n6_7 n7_7 1k
Rv6_7 n6_7 n6_8 1k
C6_7 n6_7 0 1n
D6_7 n6_7 0 DGRID
Rh7_7 n7_7 n8_7 1k
Rv7_7 n7_7 n7_8 1k
C7_7 n7_7 0 1n
D7_7 n7_7 0 DGRID
Rh8_7 n8_7 n9_7 1k
Rv8_7 n8_7 n8_8 1k
C8_7 n8_7 0 1n
D8_7 n8_7 0 DGRID
Rh9_7 n9_7 n10_7 1k
Rv9_7 n9_7 n9_8 1k
C9_7 n9_7 0 1n
D9_7 n9_7 0 DGRID
Rh10_7 n10_7 n11_7 1k
Rv10_7 n10_7 n10_8 1k
C10_7 n10_7 0 1n
D10_7 n10_7 0 DGRID
Rh11_7 n11_7 n12_7 1k
Rv11_7 n11_7 n11_8 1k
C11_7 n11_7 0 1n
D11_7 n11_7 0 DGRID
Rh12_7 n12_7 n13_7 1k
Rv12_7 n12_7 n12_8 1k
C12_7 n12_7 0 1n
D12_7 n12_7 0 DGRID
Rh13_7 n13_7 n14_7 1k
Rv13_7 n13_7 n13_8 1k
C13_7 n13_7 0 1n
D13_7 n13_7 0 DGRID
Rh14_7 n14_7 n15_7 1k
Rv14_7 n14_7 n14_8 1k
C14_7 n14_7 0 1n
D14_7 n14_7 0 DGRID
Rh15_7 n15_7 n16_7 1k
Rv15_7 n15_7 n15_8 1k
C15_7 n15_7 0 1n
D15_7 n15_7 0 DGRID
Rh16_7 n16_7 n17_7 1k
Rv16_7 n16_7 n16_8 1k
C16_7 n16_7 0 1n
D16_7 n16_7 0 DGRID
Rh17_7 n17_7 n18_7 1k
Rv17_7 n17_7 n17_8 1k
C17_7 n17_7 0 1n
D17_7 n17_7 0 DGRID
Rh18_7 n18_7 n19_7 1k
Rv18_7 n18_7 n18_8 1k
C18_7 n18_7 0 1n
D18_7 n18_7 0 DGRID
Rh19_7 n19_7 n20_7 1k
Rv19_7 n19_7 n19_8 1k
C19_7 n19_7 0 1n
D19_7 n19_7 0 DGRID
Rh20_7 n20_7 n21_7 1k
Rv20_7 n20_7 n20_8 1k
C20_7 n20_7 0 1n
D20_7 n20_7 0 DGRID
Rh21_7 n21_7 n22_7 1k
Rv21_7 n21_7 n21_8 1k
C21_7 n21_7 0 1n
D21_7 n21_7 0 DGRID
Rh22_7 n22_7 n23_7 1k
Rv22_7 n22_7 n22_8 1k
C22_7 n22_7 0 1n
D22_7 n22_7 0 DGRID
Rv23_7 n23_7 n23_8 1k
C23_7 n23_7 0 1n
D23_7 n23_7 0 DGRID
Rh0_8 n0_8 n1_8 1k
Rv0_8 n0_8 n0_9 1k
C0_8 n0_8 0 1n
D0_8 n0_8 0 DGRID
Rh1_8 n1_8 n2_8 1k
Rv1_8 n1_8 n1_9 1k
C1_8 n1_8 0 1n
D1_8 n1_8 0 DGRID
Rh2_8 n2_8 n3_8 1k
Rv2_8 n2_8 n2_9 1k
C2_8 n2_8 0 1n
D2_8 n2_8 0 DGRID
Rh3_8 n3_8 n4_8 1k
Rv3_8 n3_8 n3_9 1k
C3_8 n3_8 0 1n
D3_8 n3_8 0 DGRID
Rh4_8 n4_8 n5_8 1k
Rv4_8 n4_8 n4_9 1k
C4_8 n4_8 0 1n
D4_8 n4_8 0 DGRID
Rh5_8 n5_8 n6_8 1k
Rv5_8 n5_8 n5_9 1k
C5_8 n5_8 0 1n
D5_8 n5_8 0 DGRID
Rh6_8 n6_8 n7_8 1k
Rv6_8 n6_8 n6_9 1k
C6_8 n6_8 0 1n
D6_8 n6_8 0 DGRID
Rh7_8 n7_8 n8_8 1k
Rv7_8 n7_8 n7_9 1k
C7_8 n7_8 0 1n
D7_8 n7_8 0 DGRID
Rh8_8 n8_8 n9_8 1k
Rv8_8 n8_8 n8_9 1k
C8_8 n8_8 0 1n
D8_8 n8_8 0 DGRID
Rh9_8 n9_8 n10_8 1k
Rv9_8 n9_8 n9_9 1k
C9_8 n9_8 0 1n
D9_8 n9_8 0 DGRID
Rh10_8 n10_8 n11_8 1k
Rv10_8 n10_8 n10_9 1k
C10_8 n10_8 0 1n
D10_8 n10_8 0 DGRID
Rh11_8 n11_8 n12_8 1k
Rv11_8 n11_8 n11_9 1k
C11_8 n11_8 0 1n
D11_8 n11_8 0 DGRID
Rh12_8 n12_8 n13_8 1k
Rv12_8 n12_8 n12_9 1k
C12_8 n12_8 0 1n
D12_8 n12_8 0 DGRID
Rh13_8 n13_8 n14_8 1k
Rv13_8 n13_8 n13_9 1k
C13_8 n13_8 0 1n
D13_8 n13_8 0 DGRID
Rh14_8 n14_8 n15_8 1k
Rv14_8 n14_8 n14_9 1k
C14_8 n14_8 0 1n
D14_8 n14_8 0 DGRID
Rh15_8 n15_8 n16_8 1k
Rv15_8 n15_8 n15_9 1k
C15_8 n15_8 0 1n
D15_8 n15_8 0 DGRID
Rh16_8 n16_8 n17_8 1k
Rv16_8 n16_8 n16_9 1k
C16_8 n16_8 0 1n
D16_8 n16_8 0 DGRID
Rh17_8 n17_8 n18_8 1k
Rv17_8 n17_8 n17_9 1k
C17_8 n17_8 0 1n
D17_8 n17_8 0 DGRID
Rh18_8 n18_8 n19_8 1k
Rv18_8 n18_8 n18_9 1k
C18_8 n18_8 0 1n
D18_8 n18_8 0 DGRID
Rh19_8 n19_8 n20_8 1k
Rv19_8 n19_8 n19_9 1k
C19_8 n19_8 0 1n
D19_8 n19_8 0 DGRID
Rh20_8 n20_8 n21_8 1k
Rv20_8 n20_8 n20_9 1k
C20_8 n20_8 0 1n
D20_8 n20_8 0 DGRID
Rh21_8 n21_8 n22_8 1k
Rv21_8 n21_8 n21_9 1k
C21_8 n21_8 0 1n
D21_8 n21_8 0 DGRID
Rh22_8 n22_8 n23_8 1k
Rv22_8 n22_8 n22_9 1k
C22_8 n22_8 0 1n
D22_8 n22_8 0 DGRID
Rv23_8 n23_8 n23_9 1k
C23_8 n23_8 0 1n
D23_8 n23_8 0 DGRID
Rh0_9 n0_9 n1_9 1k
Rv0_9 n0_9 n0_10 1k
C0_9 n0_9 0 1n
D0_9 n0_9 0 DGRID
Rh1_9 n1_9 n2_9 1k
Rv1_9 n1_9 n1_10 1k
C1_9 n1_9 0 1n
D1_9 n1_9 0 DGRID
Rh2_9 n2_9 n3_9 1k
Rv2_9 n2_9 n2_10 1k
C2_9 n2_9 0 1n
D2_9 n2_9 0 DGRID
Rh3_9 n3_9 n4_9 1k
Rv3_9 n3_9 n3_10 1k
C3_9 n3_9 0 1n
D3_9 n3_9 0 DGRID
Rh4_9 n4_9 n5_9 1k
Rv4_9 n4_9 n4_10 1k
C4_9 n4_9 0 1n
D4_9 n4_9 0 DGRID
Rh5_9 n5_9 n6_9 1k
Rv5_9 n5_9 n5_10 1k
C5_9 n5_9 0 1n
D5_9 n5_9 0 DGRID
Rh6_9 n6_9 n7_9 1k
Rv6_9 n6_9 n6_10 1k
C6_9 n6_9 0 1n
D6_9 n6_9 0 DGRID
Rh7_9 n7_9 n8_9 1k
Rv7_9 n7_9 n7_10 1k
C7_9 n7_9 0 1n
D7_9 n7_9 0 DGRID
Rh8_9 n8_9 n9_9 1k
Rv8_9 n8_9 n8_10 1k
C8_9 n8_9 0 1n
D8_9 n8_9 0 DGRID
Rh9_9 n9_9 n10_9 1k
Rv9_9 n9_9 n9_10 1k
C9_9 n9_9 0 1n
D9_9 n9_9 0 DGRID
Rh10_9 n10_9 n11_9 1k
Rv10_9 n10_9 n10_10 1k
C10_9 n10_9 0 1n
D10_9 n10_9 0 DGRID
Rh11_9 n11_9 n12_9 1k
Rv11_9 n11_9 n11_10 1k
C11_9 n11_9 0 1n
D11_9 n11_9 0 DGRID
Rh12_9 n12_9 n13_9 1k
Rv12_9 n12_9 n12_10 1k
C12_9 n12_9 0 1n
D12_9 n12_9 0 DGRID
Rh13_9 n13_9 n14_9 1k
Rv13_9 n13_9 n13_10 1k
C13_9 n13_9 0 1n
D13_9 n13_9 0 DGRID
Rh14_9 n14_9 n15_9 1k
Rv14_9 n14_9 n14_10 1k
C14_9 n14_9 0 1n
D14_9 n14_9 0 DGRID
Rh15_9 n15_9 n16_9 1k
Rv15_9 n15_9 n15_10 1k
C15_9 n15_9 0 1n
D15_9 n15_9 0 DGRID
Rh16_9 n16_9 n17_9 1k
Rv16_9 n16_9 n16_10 1k
C16_9 n16_9 0 1n
D16_9 n16_9 0 DGRID
Rh17_9 n17_9 n18_9 1k
Rv17_9 n17_9 n17_10 1k
C17_9 n17_9 0 1n
D17_9 n17_9 0 DGRID
Rh18_9 n18_9 n19_9 1k
Rv18_9 n18_9 n18_10 1k
C18_9 n18_9 0 1n
D18_9 n18_9 0 DGRID
Rh19_9 n19_9 n20_9 1k
Rv19_9 n19_9 n19_10 1k
C19_9 n19_9 0 1n
D19_9 n19_9 0 DGRID
Rh20_9 n20_9 n21_9 1k
Rv20_9 n20_9 n20_10 1k
C20_9 n20_9 0 1n
D20_9 n20_9 0 DGRID
Rh21_9 n21_9 n22_9 1k
Rv21_9 n21_9 n21_10 1k
C21_9 n21_9 0 1n
D21_9 n21_9 0 DGRID
Rh22_9 n22_9 n23_9 1k
Rv22_9 n22_9 n22_10 1k
C22_9 n22_9 0 1n
D22_9 n22_9 0 DGRID
Rv23_9 n23_9 n23_10 1k
C23_9 n23_9 0 1n
D23_9 n23_9 0 DGRID
Rh0_10 n0_10 n1_10 1k
Rv0_10 n0_10 n0_11 1k
C0_10 n0_10 0 1n
D0_10 n0_10 0 DGRID
Rh1_10 n1_10 n2_10 1k
Rv1_10 n1_10 n1_11 1k
C1_10 n1_10 0 1n
D1_10 n1_10 0 DGRID
Rh2_10 n2_10 n3_10 1k
Rv2_10 n2_10 n2_11 1k
C2_10 n2_10 0 1n
D2_10 n2_10 0 DGRID
Rh3_10 n3_10 n4_10 1k
Rv3_10 n3_10 n3_11 1k
C3_10 n3_10 0 1n
D3_10 n3_10 0 DGRID
Rh4_10 n4_10 n5_10 1k
Rv4_10 n4_10 n4_11 1k
C4_10 n4_10 0 1n
D4_10 n4_10 0 DGRID
Rh5_10 n5_10 n6_10 1k
Rv5_10 n5_10 n5_11 1k
C5_10 n5_10 0 1n
D5_10 n5_10 0 DGRID
Rh6_10 n6_10 n7_10 1k
Rv6_10 n6_10 n6_11 1k
C6_10 n6_10 0 1n
D6_10 n6_10 0 DGRID
Rh7_10 n7_10 n8_10 1k
Rv7_10 n7_10 n7_11 1k
C7_10 n7_10 0 1n
D7_10 n7_10 0 DGRID
Rh8_10 n8_10 n9_10 1k
Rv8_10 n8_10 n8_11 1k
C8_10 n8_10 0 1n
D8_10 n8_10 0 DGRID
Rh9_10 n9_10 n10_10 1k
Rv9_10 n9_10 n9_11 1k
C9_10 n9_10 0 1n
D9_10 n9_10 0 DGRID
Rh10_10 n10_10 n11_10 1k
Rv10_10 n10_10 n10_11 1k
C10_10 n10_10 0 1n
D10_10 n10_10 0 DGRID
Rh11_10 n11_10 n12_10 1k
Rv11_10 n11_10 n11_11 1k
C11_10 n11_10 0 1n
D11_10 n11_10 0 DGRID
Rh12_10 n12_10 n13_10 1k
Rv12_10 n12_10 n12_11 1k
C12_10 n12_10 0 1n
D12_10 n12_10 0 DGRID
Rh13_10 n13_10 n14_10 1k
Rv13_10 n13_10 n13_11 1k
C13_10 n13_10 0 1n
D13_10 n13_10 0 DGRID
Rh14_10 n14_10 n15_10 1k
Rv14_10 n14_10 n14_11 1k
C14_10 n14_10 0 1n
D14_10 n14_10 0 DGRID
Rh15_10 n15_10 n16_10 1k
Rv15_10 n15_10 n15_11 1k
C15_10 n15_10 0 1n
D15_10 n15_10 0 DGRID
Rh16_10 n16_10 n17_10 1k
Rv16_10 n16_10 n16_11 1k
C16_10 n16_10 0 1n
D16_10 n16_10 0 DGRID
Rh17_10 n17_10 n18_10 1k
Rv17_10 n17_10 n17_11 1k
C17_10 n17_10 0 1n
D17_10 n17_10 0 DGRID
Rh18_10 n18_10 n19_10 1k
Rv18_10 n18_10 n18_11 1k
C18_10 n18_10 0 1n
D18_10 n18_10 0 DGRID
Rh19_10 n19_10 n20_10 1k
Rv19_10 n19_10 n19_11 1k
C19_10 n19_10 0 1n
D19_10 n19_10 0 DGRID
Rh20_10 n20_10 n21_10 1k
Rv20_10 n20_10 n20_11 1k
C20_10 n20_10 0 1n
D20_10 n20_10 0 DGRID
Rh21_10 n21_10 n22_10 1k
Rv21_10 n21_10 n21_11 1k
C21_10 n21_10 0 1n
D21_10 n21_10 0 DGRID
Rh22_10 n22_10 n23_10 1k
Rv22_10 n22_10 n22_11 1k
C22_10 n22_10 0 1n
D22_10 n22_10 0 DGRID
Rv23_10 n23_10 n23_11 1k
C23_10 n23_10 0 1n
D23_10 n23_10 0 DGRID
Rh0_11 n0_11 n1_11 1k
Rv0_11 n0_11 n0_12 1k
C0_11 n0_11 0 1n
D0_11 n0_11 0 DGRID
Rh1_11 n1_11 n2_11 1k
Rv1_11 n1_11 n1_12 1k
C1_11 n1_11 0 1n
D1_11 n1_11 0 DGRID
Rh2_11 n2_11 n3_11 1k
Rv2_11 n2_11 n2_12 1k
C2_11 n2_11 0 1n
D2_11 n2_11 0 DGRID
Rh3_11 n3_11 n4_11 1k
Rv3_11 n3_11 n3_12 1k
C3_11 n3_11 0 1n
D3_11 n3_11 0 DGRID
Rh4_11 n4_11 n5_11 1k
Rv4_11 n4_11 n4_12 1k
C4_11 n4_11 0 1n
D4_11 n4_11 0 DGRID
Rh5_11 n5_11 n6_11 1k
Rv5_11 n5_11 n5_12 1k
C5_11 n5_11 0 1n
D5_11 n5_11 0 DGRID
Rh6_11 n6_11 n7_11 1k
Rv6_11 n6_11 n6_12 1k
C6_11 n6_11 0 1n
D6_11 n6_11 0 DGRID
Rh7_11 n7_11 n8_11 1k
Rv7_11 n7_11 n7_12 1k
C7_11 n7_11 0 1n
D7_11 n7_11 0 DGRID
Rh8_11 n8_11 n9_11 1k
Rv8_11 n8_11 n8_12 1k
C8_11 n8_11 0 1n
D8_11 n8_11 0 DGRID
Rh9_11 n9_11 n10_11 1k
Rv9_11 n9_11 n9_12 1k
C9_11 n9_11 0 1n
D9_11 n9_11 0 DGRID
Rh10_11 n10_11 n11_11 1k
Rv10_11 n10_11 n10_12 1k
C10_11 n10_11 0 1n
D10_11 n10_11 0 DGRID
Rh11_11 n11_11 n12_11 1k
Rv11_11 n11_11 n11_12 1k
C11_11 n11_11 0 1n
D11_11 n11_11 0 DGRID
Rh12_11 n12_11 n13_11 1k
Rv12_11 n12_11 out 1k
C12_11 n12_11 0 1n
D12_11 n12_11 0 DGRID
Rh13_11 n13_11 n14_11 1k
Rv13_11 n13_11 n13_12 1k
C13_11 n13_11 0 1n
D13_11 n13_11 0 DGRID
Rh14_11 n14_11 n15_11 1k
Rv14_11 n14_11 n14_12 1k
C14_11 n14_11 0 1n
D14_11 n14_11 0 DGRID
Rh15_11 n15_11 n16_11 1k
Rv15_11 n15_11 n15_12 1k
C15_11 n15_11 0 1n
D15_11 n15_11 0 DGRID
Rh16_11 n16_11 n17_11 1k
Rv16_11 n16_11 n16_12 1k
C16_11 n16_11 0 1n
D16_11 n16_11 0 DGRID
Rh17_11 n17_11 n18_11 1k
Rv17_11 n17_11 n17_12 1k
C17_11 n17_11 0 1n
D17_11 n17_11 0 DGRID
Rh18_11 n18_11 n19_11 1k
Rv18_11 n18_11 n18_12 1k
C18_11 n18_11 0 1n
D18_11 n18_11 0 DGRID
Rh19_11 n19_11 n20_11 1k
Rv19_11 n19_11 n19_12 1k
C19_11 n19_11 0 1n
D19_11 n19_11 0 DGRID
Rh20_11 n20_11 n21_11 1k
Rv20_11 n20_11 n20_12 1k
C20_11 n20_11 0 1n
D20_11 n20_11 0 DGRID
Rh21_11 n21_11 n22_11 1k
Rv21_11 n21_11 n21_12 1k
C21_11 n21_11 0 1n
D21_11 n21_11 0 DGRID
Rh22_11 n22_11 n23_11 1k
Rv22_11 n22_11 n22_12 1k
C22_11 n22_11 0 1n
D22_11 n22_11 0 DGRID
Rv23_11 n23_11 n23_12 1k
C23_11 n23_11 0 1n
D23_11 n23_11 0 DGRID
Rh0_12 n0_12 n1_12 1k
Rv0_12 n0_12 n0_13 1k
C0_12 n0_12 0 1n
D0_12 n0_12 0 DGRID
Rh1_12 n1_12 n2_12 1k
Rv1_12 n1_12 n1_13 1k
C1_12 n1_12 0 1n
D1_12 n1_12 0 DGRID
Rh2_12 n2_12 n3_12 1k
Rv2_12 n2_12 n2_13 1k
C2_12 n2_12 0 1n
D2_12 n2_12 0 DGRID
Rh3_12 n3_12 n4_12 1k
Rv3_12 n3_12 n3_13 1k
C3_12 n3_12 0 1n
D3_12 n3_12 0 DGRID
Rh4_12 n4_12 n5_12 1k
Rv4_12 n4_12 n4_13 1k
C4_12 n4_12 0 1n
D4_12 n4_12 0 DGRID
Rh5_12 n5_12 n6_12 1k
Rv5_12 n5_12 n5_13 1k
C5_12 n5_12 0 1n
D5_12 n5_12 0 DGRID
Rh6_12 n6_12 n7_12 1k
Rv6_12 n6_12 n6_13 1k
C6_12 n6_12 0 1n
D6_12 n6_12 0 DGRID
Rh7_12 n7_12 n8_12 1k
Rv7_12 n7_12 n7_13 1k
C7_12 n7_12 0 1n
D7_12 n7_12 0 DGRID
Rh8_12 n8_12 n9_12 1k
Rv8_12 n8_12 n8_13 1k
C8_12 n8_12 0 1n
D8_12 n8_12 0 DGRID
Rh9_12 n9_12 n10_12 1k
Rv9_12 n9_12 n9_13 1k
C9_12 n9_12 0 1n
D9_12 n9_12 0 DGRID
Rh10_12 n10_12 n11_12 1k
Rv10_12 n10_12 n10_13 1k
C10_12 n10_12 0 1n
D10_12 n10_12 0 DGRID
Rh11_12 n11_12 out 1k
Rv11_12 n11_12 n11_13 1k
C11_12 n11_12 0 1n
D11_12 n11_12 0 DGRID
Rh12_12 out n13_12 1k
Rv12_12 out n12_13 1k
C12_12 out 0 1n
D12_12 out 0 DGRID
Rh13_12 n13_12 n14_12 1k
Rv13_12 n13_12 n13_13 1k
C13_12 n13_12 0 1n
D13_12 n13_12 0 DGRID
Rh14_12 n14_12 n15_12 1k
Rv14_12 n14_12 n14_13 1k
C14_12 n14_12 0 1n
D14_12 n14_12 0 DGRID
Rh15_12 n15_12 n16_12 1k
Rv15_12 n15_12 n15_13 1k
C15_12 n15_12 0 1n
D15_12 n15_12 0 DGRID
Rh16_12 n16_12 n17_12 1k
Rv16_12 n16_12 n16_13 1k
C16_12 n16_12 0 1n
D16_12 n16_12 0 DGRID
Rh17_12 n17_12 n18_12 1k
Rv17_12 n17_12 n17_13 1k
C17_12 n17_12 0 1n
D17_12 n17_12 0 DGRID
Rh18_12 n18_12 n19_12 1k
Rv18_12 n18_12 n18_13 1k
C18_12 n18_12 0 1n
D18_12 n18_12 0 DGRID
Rh19_12 n19_12 n20_12 1k
Rv19_12 n19_12 n19_13 1k
C19_12 n19_12 0 1n
D19_12 n19_12 0 DGRID
Rh20_12 n20_12 n21_12 1k
Rv20_12 n20_12 n20_13 1k
C20_12 n20_12 0 1n
D20_12 n20_12 0 DGRID
Rh21_12 n21_12 n22_12 1k
Rv21_12 n21_12 n21_13 1k
C21_12 n21_12 0 1n
D21_12 n21_12 0 DGRID
Rh22_12 n22_12 n23_12 1k
Rv22_12 n22_12 n22_13 1k
C22_12 n22_12 0 1n
D22_12 n22_12 0 DGRID
Rv23_12 n23_12 n23_13 1k
C23_12 n23_12 0 1n
D23_12 n23_12 0 DGRID
Rh0_13 n0_13 n1_13 1k
Rv0_13 n0_13 n0_14 1k
C0_13 n0_13 0 1n
D0_13 n0_13 0 DGRID
Rh1_13 n1_13 n2_13 1k
Rv1_13 n1_13 n1_14 1k
C1_13 n1_13 0 1n
D1_13 n1_13 0 DGRID
Rh2_13 n2_13 n3_13 1k
Rv2_13 n2_13 n2_14 1k
C2_13 n2_13 0 1n
D2_13 n2_13 0 DGRID
Rh3_13 n3_13 n4_13 1k
Rv3_13 n3_13 n3_14 1k
C3_13 n3_13 0 1n
D3_13 n3_13 0 DGRID
Rh4_13 n4_13 n5_13 1k
Rv4_13 n4_13 n4_14 1k
C4_13 n4_13 0 1n
D4_13 n4_13 0 DGRID
Rh5_13 n5_13 n6_13 1k
Rv5_13 n5_13 n5_14 1k
C5_13 n5_13 0 1n
D5_13 n5_13 0 DGRID
Rh6_13 n6_13 n7_13 1k
Rv6_13 n6_13 n6_14 1k
C6_13 n6_13 0 1n
D6_13 n6_13 0 DGRID
Rh7_13 n7_13 n8_13 1k
Rv7_13 n7_13 n7_14 1k
C7_13 n7_13 0 1n
D7_13 n7_13 0 DGRID
Rh8_13 n8_13 n9_13 1k
Rv8_13 n8_13 n8_14 1k
C8_13 n8_13 0 1n
D8_13 n8_13 0 DGRID
Rh9_13 n9_13 n10_13 1k
Rv9_13 n9_13 n9_14 1k
C9_13 n9_13 0 1n
D9_13 n9_13 0 DGRID
Rh10_13 n10_13 n11_13 1k
Rv10_13 n10_13 n10_14 1k
C10_13 n10_13 0 1n
D10_13 n10_13 0 DGRID
Rh11_13 n11_13 n12_13 1k
Rv11_13 n11_13 n11_14 1k
C11_13 n11_13 0 1n
D11_13 n11_13 0 DGRID
Rh12_13 n12_13 n13_13 1k
Rv12_13 n12_13 n12_14 1k
C12_13 n12_13 0 1n
D12_13 n12_13 0 DGRID
Rh13_13 n13_13 n14_13 1k
Rv13_13 n13_13 n13_14 1k
C13_13 n13_13 0 1n
D13_13 n13_13 0 DGRID
Rh14_13 n14_13 n15_13 1k
Rv14_13 n14_13 n14_14 1k
C14_13 n14_13 0 1n
D14_13 n14_13 0 DGRID
Rh15_13 n15_13 n16_13 1k
Rv15_13 n15_13 n15_14 1k
C15_13 n15_13 0 1n
D15_13 n15_13 0 DGRID
Rh16_13 n16_13 n17_13 1k
Rv16_13 n16_13 n16_14 1k
C16_13 n16_13 0 1n
D16_13 n16_13 0 DGRID
Rh17_13 n17_13 n18_13 1k
Rv17_13 n17_13 n17_14 1k
C17_13 n17_13 0 1n
D17_13 n17_13 0 DGRID
Rh18_13 n18_13 n19_13 1k
Rv18_13 n18_13 n18_14 1k
C18_13 n18_13 0 1n
D18_13 n18_13 0 DGRID
Rh19_13 n19_13 n20_13 1k
Rv19_13 n19_13 n19_14 1k
C19_13 n19_13 0 1n
D19_13 n19_13 0 DGRID
Rh20_13 n20_13 n21_13 1k
Rv20_13 n20_13 n20_14 1k
C20_13 n20_13 0 1n
D20_13 n20_13 0 DGRID
Rh21_13 n21_13 n22_13 1k
Rv21_13 n21_13 n21_14 1k
C21_13 n21_13 0 1n
D21_13 n21_13 0 DGRID
Rh22_13 n22_13 n23_13 1k
Rv22_13 n22_13 n22_14 1k
C22_13 n22_13 0 1n
D22_13 n22_13 0 DGRID
Rv23_13 n23_13 n23_14 1k
C23_13 n23_13 0 1n
D23_13 n23_13 0 DGRID
Rh0_14 n0_14 n1_14 1k
Rv0_14 n0_14 n0_15 1k
C0_14 n0_14 0 1n
D0_14 n0_14 0 DGRID
Rh1_14 n1_14 n2_14 1k
Rv1_14 n1_14 n1_15 1k
C1_14 n1_14 0 1n
D1_14 n1_14 0 DGRID
Rh2_14 n2_14 n3_14 1k
Rv2_14 n2_14 n2_15 1k
C2_14 n2_14 0 1n
D2_14 n2_14 0 DGRID
Rh3_14 n3_14 n4_14 1k
Rv3_14 n3_14 n3_15 1k
C3_14 n3_14 0 1n
D3_14 n3_14 0 DGRID
Rh4_14 n4_14 n5_14 1k
Rv4_14 n4_14 n4_15 1k
C4_14 n4_14 0 1n
D4_14 n4_14 0 DGRID
Rh5_14 n5_14 n6_14 1k
Rv5_14 n5_14 n5_15 1k
C5_14 n5_14 0 1n
D5_14 n5_14 0 DGRID
Rh6_14 n6_14 n7_14 1k
Rv6_14 n6_14 n6_15 1k
C6_14 n6_14 0 1n
D6_14 n6_14 0 DGRID
Rh7_14 n7_14 n8_14 1k
Rv7_14 n7_14 n7_15 1k
C7_14 n7_14 0 1n
D7_14 n7_14 0 DGRID
Rh8_14 n8_14 n9_14 1k
Rv8_14 n8_14 n8_15 1k
C8_14 n8_14 0 1n
D8_14 n8_14 0 DGRID
Rh9_14 n9_14 n10_14 1k
Rv9_14 n9_14 n9_15 1k
C9_14 n9_14 0 1n
D9_14 n9_14 0 DGRID
Rh10_14 n10_14 n11_14 1k
Rv10_14 n10_14 n10_15 1k
C10_14 n10_14 0 1n
D10_14 n10_14 0 DGRID
Rh11_14 n11_14 n12_14 1k
Rv11_14 n11_14 n11_15 1k
C11_14 n11_14 0 1n
D11_14 n11_14 0 DGRID
Rh12_14 n12_14 n13_14 1k
Rv12_14 n12_14 n12_15 1k
C12_14 n12_14 0 1n
D12_14 n12_14 0 DGRID
Rh13_14 n13_14 n14_14 1k
Rv13_14 n13_14 n13_15 1k
C13_14 n13_14 0 1n
D13_14 n13_14 0 DGRID
Rh14_14 n14_14 n15_14 1k
Rv14_14 n14_14 n14_15 1k
C14_14 n14_14 0 1n
D14_14 n14_14 0 DGRID
Rh15_14 n15_14 n16_14 1k
Rv15_14 n15_14 n15_15 1k
C15_14 n15_14 0 1n
D15_14 n15_14 0 DGRID
Rh16_14 n16_14 n17_14 1k
Rv16_14 n16_14 n16_15 1k
C16_14 n16_14 0 1n
D16_14 n16_14 0 DGRID
Rh17_14 n17_14 n18_14 1k
Rv17_14 n17_14 n17_15 1k
C17_14 n17_14 0 1n
D17_14 n17_14 0 DGRID
Rh18_14 n18_14 n19_14 1k
Rv18_14 n18_14 n18_15 1k
C18_14 n18_14 0 1n
D18_14 n18_14 0 DGRID
Rh19_14 n19_14 n20_14 1k
Rv19_14 n19_14 n19_15 1k
C19_14 n19_14 0 1n
D19_14 n19_14 0 DGRID
Rh20_14 n20_14 n21_14 1k
Rv20_14 n20_14 n20_15 1k
C20_14 n20_14 0 1n
D20_14 n20_14 0 DGRID
Rh21_14 n21_14 n22_14 1k
Rv21_14 n21_14 n21_15 1k
C21_14 n21_14 0 1n
D21_14 n21_14 0 DGRID
Rh22_14 n22_14 n23_14 1k
Rv22_14 n22_14 n22_15 1k
C22_14 n22_14 0 1n
D22_14 n22_14 0 DGRID
Rv23_14 n23_14 n23_15 1k
C23_14 n23_14 0 1n
D23_14 n23_14 0 DGRID
Rh0_15 n0_15 n1_15 1k
Rv0_15 n0_15 n0_16 1k
C0_15 n0_15 0 1n
D0_15 n0_15 0 DGRID
Rh1_15 n1_15 n2_15 1k
Rv1_15 n1_15 n1_16 1k
C1_15 n1_15 0 1n
D1_15 n1_15 0 DGRID
Rh2_15 n2_15 n3_15 1k
Rv2_15 n2_15 n2_16 1k
C2_15 n2_15 0 1n
D2_15 n2_15 0 DGRID
Rh3_15 n3_15 n4_15 1k
Rv3_15 n3_15 n3_16 1k
C3_15 n3_15 0 1n
D3_15 n3_15 0 DGRID
Rh4_15 n4_15 n5_15 1k
Rv4_15 n4_15 n4_16 1k
C4_15 n4_15 0 1n
D4_15 n4_15 0 DGRID
Rh5_15 n5_15 n6_15 1k
Rv5_15 n5_15 n5_16 1k
C5_15 n5_15 0 1n
D5_15 n5_15 0 DGRID
Rh6_15 n6_15 n7_15 1k
Rv6_15 n6_15 n6_16 1k
C6_15 n6_15 0 1n
D6_15 n6_15 0 DGRID
Rh7_15 n7_15 n8_15 1k
Rv7_15 n7_15 n7_16 1k
C7_15 n7_15 0 1n
D7_15 n7_15 0 DGRID
Rh8_15 n8_15 n9_15 1k
Rv8_15 n8_15 n8_16 1k
C8_15 n8_15 0 1n
D8_15 n8_15 0 DGRID
Rh9_15 n9_15 n10_15 1k
Rv9_15 n9_15 n9_16 1k
C9_15 n9_15 0 1n
D9_15 n9_15 0 DGRID
Rh10_15 n10_15 n11_15 1k
Rv10_15 n10_15 n10_16 1k
C10_15 n10_15 0 1n
D10_15 n10_15 0 DGRID
Rh11_15 n11_15 n12_15 1k
Rv11_15 n11_15 n11_16 1k
C11_15 n11_15 0 1n
D11_15 n11_15 0 DGRID
Rh12_15 n12_15 n13_15 1k
Rv12_15 n12_15 n12_16 1k
C12_15 n12_15 0 1n
D12_15 n12_15 0 DGRID
Rh13_15 n13_15 n14_15 1k
Rv13_15 n13_15 n13_16 1k
C13_15 n13_15 0 1n
D13_15 n13_15 0 DGRID
Rh14_15 n14_15 n15_15 1k
Rv14_15 n14_15 n14_16 1k
C14_15 n14_15 0 1n
D14_15 n14_15 0 DGRID
Rh15_15 n15_15 n16_15 1k
Rv15_15 n15_15 n15_16 1k
C15_15 n15_15 0 1n
D15_15 n15_15 0 DGRID
Rh16_15 n16_15 n17_15 1k
Rv16_15 n16_15 n16_16 1k
C16_15 n16_15 0 1n
D16_15 n16_15 0 DGRID
Rh17_15 n17_15 n18_15 1k
Rv17_15 n17_15 n17_16 1k
C17_15 n17_15 0 1n
D17_15 n17_15 0 DGRID
Rh18_15 n18_15 n19_15 1k
Rv18_15 n18_15 n18_16 1k
C18_15 n18_15 0 1n
D18_15 n18_15 0 DGRID
Rh19_15 n19_15 n20_15 1k
Rv19_15 n19_15 n19_16 1k
C19_15 n19_15 0 1n
D19_15 n19_15 0 DGRID
Rh20_15 n20_15 n21_15 1k
Rv20_15 n20_15 n20_16 1k
C20_15 n20_15 0 1n
D20_15 n20_15 0 DGRID
Rh21_15 n21_15 n22_15 1k
Rv21_15 n21_15 n21_16 1k
C21_15 n21_15 0 1n
D21_15 n21_15 0 DGRID
Rh22_15 n22_15 n23_15 1k
Rv22_15 n22_15 n22_16 1k
C22_15 n22_15 0 1n
D22_15 n22_15 0 DGRID
Rv23_15 n23_15 n23_16 1k
C23_15 n23_15 0 1n
D23_15 n23_15 0 DGRID
Rh0_16 n0_16 n1_16 1k
Rv0_16 n0_16 n0_17 1k
C0_16 n0_16 0 1n
D0_16 n0_16 0 DGRID
Rh1_16 n1_16 n2_16 1k
Rv1_16 n1_16 n1_17 1k
C1_16 n1_16 0 1n
D1_16 n1_16 0 DGRID
Rh2_16 n2_16 n3_16 1k
Rv2_16 n2_16 n2_17 1k
C2_16 n2_16 0 1n
D2_16 n2_16 0 DGRID
Rh3_16 n3_16 n4_16 1k
Rv3_16 n3_16 n3_17 1k
C3_16 n3_16 0 1n
D3_16 n3_16 0 DGRID
Rh4_16 n4_16 n5_16 1k
Rv4_16 n4_16 n4_17 1k
C4_16 n4_16 0 1n
D4_16 n4_16 0 DGRID
Rh5_16 n5_16 n6_16 1k
Rv5_16 n5_16 n5_17 1k
C5_16 n5_16 0 1n
D5_16 n5_16 0 DGRID
Rh6_16 n6_16 n7_16 1k
Rv6_16 n6_16 n6_17 1k
C6_16 n6_16 0 1n
D6_16 n6_16 0 DGRID
Rh7_16 n7_16 n8_16 1k
Rv7_16 n7_16 n7_17 1k
C7_16 n7_16 0 1n
D7_16 n7_16 0 DGRID
Rh8_16 n8_16 n9_16 1k
Rv8_16 n8_16 n8_17 1k
C8_16 n8_16 0 1n
D8_16 n8_16 0 DGRID
Rh9_16 n9_16 n10_16 1k
Rv9_16 n9_16 n9_17 1k
C9_16 n9_16 0 1n
D9_16 n9_16 0 DGRID
Rh10_16 n10_16 n11_16 1k
Rv10_16 n10_16 n10_17 1k
C10_16 n10_16 0 1n
D10_16 n10_16 0 DGRID
Rh11_16 n11_16 n12_16 1k
Rv11_16 n11_16 n11_17 1k
C11_16 n11_16 0 1n
D11_16 n11_16 0 DGRID
Rh12_16 n12_16 n13_16 1k
Rv12_16 n12_16 n12_17 1k
C12_16 n12_16 0 1n
D12_16 n12_16 0 DGRID
Rh13_16 n13_16 n14_16 1k
Rv13_16 n13_16 n13_17 1k
C13_16 n13_16 0 1n
D13_16 n13_16 0 DGRID
Rh14_16 n14_16 n15_16 1k
Rv14_16 n14_16 n14_17 1k
C14_16 n14_16 0 1n
D14_16 n14_16 0 DGRID
Rh15_16 n15_16 n16_16 1k
Rv15_16 n15_16 n15_17 1k
C15_16 n15_16 0 1n
D15_16 n15_16 0 DGRID
Rh16_16 n16_16 n17_16 1k
Rv16_16 n16_16 n16_17 1k
C16_16 n16_16 0 1n
D16_16 n16_16 0 DGRID
Rh17_16 n17_16 n18_16 1k
Rv17_16 n17_16 n17_17 1k
C17_16 n17_16 0 1n
D17_16 n17_16 0 DGRID
Rh18_16 n18_16 n19_16 1k
Rv18_16 n18_16 n18_17 1k
C18_16 n18_16 0 1n
D18_16 n18_16 0 DGRID
Rh19_16 n19_16 n20_16 1k
Rv19_16 n19_16 n19_17 1k
C19_16 n19_16 0 1n
D19_16 n19_16 0 DGRID
Rh20_16 n20_16 n21_16 1k
Rv20_16 n20_16 n20_17 1k
C20_16 n20_16 0 1n
D20_16 n20_16 0 DGRID
Rh21_16 n21_16 n22_16 1k
Rv21_16 n21_16 n21_17 1k
C21_16 n21_16 0 1n
D21_16 n21_16 0 DGRID
Rh22_16 n22_16 n23_16 1k
Rv22_16 n22_16 n22_17 1k
C22_16 n22_16 0 1n
D22_16 n22_16 0 DGRID
Rv23_16 n23_16 n23_17 1k
C23_16 n23_16 0 1n
D23_16 n23_16 0 DGRID
Rh0_17 n0_17 n1_17 1k
Rv0_17 n0_17 n0_18 1k
C0_17 n0_17 0 1n
D0_17 n0_17 0 DGRID
Rh1_17 n1_17 n2_17 1k
Rv1_17 n1_17 n1_18 1k
C1_17 n1_17 0 1n
D1_17 n1_17 0 DGRID
Rh2_17 n2_17 n3_17 1k
Rv2_17 n2_17 n2_18 1k
C2_17 n2_17 0 1n
D2_17 n2_17 0 DGRID
Rh3_17 n3_17 n4_17 1k
Rv3_17 n3_17 n3_18 1k
C3_17 n3_17 0 1n
D3_17 n3_17 0 DGRID
Rh4_17 n4_17 n5_17 1k
Rv4_17 n4_17 n4_18 1k
C4_17 n4_17 0 1n
D4_17 n4_17 0 DGRID
Rh5_17 n5_17 n6_17 1k
Rv5_17 n5_17 n5_18 1k
C5_17 n5_17 0 1n
D5_17 n5_17 0 DGRID
Rh6_17 n6_17 n7_17 1k
Rv6_17 n6_17 n6_18 1k
C6_17 n6_17 0 1n
D6_17 n6_17 0 DGRID
Rh7_17 n7_17 n8_17 1k
Rv7_17 n7_17 n7_18 1k
C7_17 n7_17 0 1n
D7_17 n7_17 0 DGRID
Rh8_17 n8_17 n9_17 1k
Rv8_17 n8_17 n8_18 1k
C8_17 n8_17 0 1n
D8_17 n8_17 0 DGRID
Rh9_17 n9_17 n10_17 1k
Rv9_17 n9_17 n9_18 1k
C9_17 n9_17 0 1n
D9_17 n9_17 0 DGRID
Rh10_17 n10_17 n11_17 1k
Rv10_17 n10_17 n10_18 1k
C10_17 n10_17 0 1n
D10_17 n10_17 0 DGRID
Rh11_17 n11_17 n12_17 1k
Rv11_17 n11_17 n11_18 1k
C11_17 n11_17 0 1n
D11_17 n11_17 0 DGRID
Rh12_17 n12_17 n13_17 1k
Rv12_17 n12_17 n12_18 1k
C12_17 n12_17 0 1n
D12_17 n12_17 0 DGRID
Rh13_17 n13_17 n14_17 1k
Rv13_17 n13_17 n13_18 1k
C13_17 n13_17 0 1n
D13_17 n13_17 0 DGRID
Rh14_17 n14_17 n15_17 1k
Rv14_17 n14_17 n14_18 1k
C14_17 n14_17 0 1n
D14_17 n14_17 0 DGRID
Rh15_17 n15_17 n16_17 1k
Rv15_17 n15_17 n15_18 1k
C15_17 n15_17 0 1n
D15_17 n15_17 0 DGRID
Rh16_17 n16_17 n17_17 1k
Rv16_17 n16_17 n16_18 1k
C16_17 n16_17 0 1n
D16_17 n16_17 0 DGRID
Rh17_17 n17_17 n18_17 1k
Rv17_17 n17_17 n17_18 1k
C17_17 n17_17 0 1n
D17_17 n17_17 0 DGRID
Rh18_17 n18_17 n19_17 1k
Rv18_17 n18_17 n18_18 1k
C18_17 n18_17 0 1n
D18_17 n18_17 0 DGRID
Rh19_17 n19_17 n20_17 1k
Rv19_17 n19_17 n19_18 1k
C19_17 n19_17 0 1n
D19_17 n19_17 0 DGRID
Rh20_17 n20_17 n21_17 1k
Rv20_17 n20_17 n20_18 1k
C20_17 n20_17 0 1n
D20_17 n20_17 0 DGRID
Rh21_17 n21_17 n22_17 1k
Rv21_17 n21_17 n21_18 1k
C21_17 n21_17 0 1n
D21_17 n21_17 0 DGRID
Rh22_17 n22_17 n23_17 1k
Rv22_17 n22_17 n22_18 1k
C22_17 n22_17 0 1n
D22_17 n22_17 0 DGRID
Rv23_17 n23_17 n23_18 1k
C23_17 n23_17 0 1n
D23_17 n23_17 0 DGRID
Rh0_18 n0_18 n1_18 1k
Rv0_18 n0_18 n0_19 1k
C0_18 n0_18 0 1n
D0_18 n0_18 0 DGRID
Rh1_18 n1_18 n2_18 1k
Rv1_18 n1_18 n1_19 1k
C1_18 n1_18 0 1n
D1_18 n1_18 0 DGRID
Rh2_18 n2_18 n3_18 1k
Rv2_18 n2_18 n2_19 1k
C2_18 n2_18 0 1n
D2_18 n2_18 0 DGRID
Rh3_18 n3_18 n4_18 1k
Rv3_18 n3_18 n3_19 1k
C3_18 n3_18 0 1n
D3_18 n3_18 0 DGRID
Rh4_18 n4_18 n5_18 1k
Rv4_18 n4_18 n4_19 1k
C4_18 n4_18 0 1n
D4_18 n4_18 0 DGRID
Rh5_18 n5_18 n6_18 1k
Rv5_18 n5_18 n5_19 1k
C5_18 n5_18 0 1n
D5_18 n5_18 0 DGRID
Rh6_18 n6_18 n7_18 1k
Rv6_18 n6_18 n6_19 1k
C6_18 n6_18 0 1n
D6_18 n6_18 0 DGRID
Rh7_18 n7_18 n8_18 1k
Rv7_18 n7_18 n7_19 1k
C7_18 n7_18 0 1n
D7_18 n7_18 0 DGRID
Rh8_18 n8_18 n9_18 1k
Rv8_18 n8_18 n8_19 1k
C8_18 n8_18 0 1n
D8_18 n8_18 0 DGRID
Rh9_18 n9_18 n10_18 1k
Rv9_18 n9_18 n9_19 1k
C9_18 n9_18 0 1n
D9_18 n9_18 0 DGRID
Rh10_18 n10_18 n11_18 1k
Rv10_18 n10_18 n10_19 1k
C10_18 n10_18 0 1n
D10_18 n10_18 0 DGRID
Rh11_18 n11_18 n12_18 1k
Rv11_18 n11_18 n11_19 1k
C11_18 n11_18 0 1n
D11_18 n11_18 0 DGRID
Rh12_18 n12_18 n13_18 1k
Rv12_18 n12_18 n12_19 1k
C12_18 n12_18 0 1n
D12_18 n12_18 0 DGRID
Rh13_18 n13_18 n14_18 1k
Rv13_18 n13_18 n13_19 1k
C13_18 n13_18 0 1n
D13_18 n13_18 0 DGRID
Rh14_18 n14_18 n15_18 1k
Rv14_18 n14_18 n14_19 1k
C14_18 n14_18 0 1n
D14_18 n14_18 0 DGRID
Rh15_18 n15_18 n16_18 1k
Rv15_18 n15_18 n15_19 1k
C15_18 n15_18 0 1n
D15_18 n15_18 0 DGRID
Rh16_18 n16_18 n17_18 1k
Rv16_18 n16_18 n16_19 1k
C16_18 n16_18 0 1n
D16_18 n16_18 0 DGRID
Rh17_18 n17_18 n18_18 1k
Rv17_18 n17_18 n17_19 1k
C17_18 n17_18 0 1n
D17_18 n17_18 0 DGRID
Rh18_18 n18_18 n19_18 1k
Rv18_18 n18_18 n18_19 1k
C18_18 n18_18 0 1n
D18_18 n18_18 0 DGRID
Rh19_18 n19_18 n20_18 1k
Rv19_18 n19_18 n19_19 1k
C19_18 n19_18 0 1n
D19_18 n19_18 0 DGRID
Rh20_18 n20_18 n21_18 1k
Rv20_18 n20_18 n20_19 1k
C20_18 n20_18 0 1n
D20_18 n20_18 0 DGRID
Rh21_18 n21_18 n22_18 1k
Rv21_18 n21_18 n21_19 1k
C21_18 n21_18 0 1n
D21_18 n21_18 0 DGRID
Rh22_18 n22_18 n23_18 1k
Rv22_18 n22_18 n22_19 1k
C22_18 n22_18 0 1n
D22_18 n22_18 0 DGRID
Rv23_18 n23_18 n23_19 1k
C23_18 n23_18 0 1n
D23_18 n23_18 0 DGRID
Rh0_19 n0_19 n1_19 1k
Rv0_19 n0_19 n0_20 1k
C0_19 n0_19 0 1n
D0_19 n0_19 0 DGRID
Rh1_19 n1_19 n2_19 1k
Rv1_19 n1_19 n1_20 1k
C1_19 n1_19 0 1n
D1_19 n1_19 0 DGRID
Rh2_19 n2_19 n3_19 1k
Rv2_19 n2_19 n2_20 1k
C2_19 n2_19 0 1n
D2_19 n2_19 0 DGRID
Rh3_19 n3_19 n4_19 1k
Rv3_19 n3_19 n3_20 1k
C3_19 n3_19 0 1n
D3_19 n3_19 0 DGRID
Rh4_19 n4_19 n5_19 1k
Rv4_19 n4_19 n4_20 1k
C4_19 n4_19 0 1n
D4_19 n4_19 0 DGRID
Rh5_19 n5_19 n6_19 1k
Rv5_19 n5_19 n5_20 1k
C5_19 n5_19 0 1n
D5_19 n5_19 0 DGRID
Rh6_19 n6_19 n7_19 1k
Rv6_19 n6_19 n6_20 1k
C6_19 n6_19 0 1n
D6_19 n6_19 0 DGRID
Rh7_19 n7_19 n8_19 1k
Rv7_19 n7_19 n7_20 1k
C7_19 n7_19 0 1n
D7_19 n7_19 0 DGRID
Rh8_19 n8_19 n9_19 1k
Rv8_19 n8_19 n8_20 1k
C8_19 n8_19 0 1n
D8_19 n8_19 0 DGRID
Rh9_19 n9_19 n10_19 1k
Rv9_19 n9_19 n9_20 1k
C9_19 n9_19 0 1n
D9_19 n9_19 0 DGRID
Rh10_19 n10_19 n11_19 1k
Rv10_19 n10_19 n10_20 1k
C10_19 n10_19 0 1n
D10_19 n10_19 0 DGRID
Rh11_19 n11_19 n12_19 1k
Rv11_19 n11_19 n11_20 1k
C11_19 n11_19 0 1n
D11_19 n11_19 0 DGRID
Rh12_19 n12_19 n13_19 1k
Rv12_19 n12_19 n12_20 1k
C12_19 n12_19 0 1n
D12_19 n12_19 0 DGRID
Rh13_19 n13_19 n14_19 1k
Rv13_19 n13_19 n13_20 1k
C13_19 n13_19 0 1n
D13_19 n13_19 0 DGRID
Rh14_19 n14_19 n15_19 1k
Rv14_19 n14_19 n14_20 1k
C14_19 n14_19 0 1n
D14_19 n14_19 0 DGRID
Rh15_19 n15_19 n16_19 1k
Rv15_19 n15_19 n15_20 1k
C15_19 n15_19 0 1n
D15_19 n15_19 0 DGRID
Rh16_19 n16_19 n17_19 1k
Rv16_19 n16_19 n16_20 1k
C16_19 n16_19 0 1n
D16_19 n16_19 0 DGRID
Rh17_19 n17_19 n18_19 1k
Rv17_19 n17_19 n17_20 1k
C17_19 n17_19 0 1n
D17_19 n17_19 0 DGRID
Rh18_19 n18_19 n19_19 1k
Rv18_19 n18_19 n18_20 1k
C18_19 n18_19 0 1n
D18_19 n18_19 0 DGRID
Rh19_19 n19_19 n20_19 1k
Rv19_19 n19_19 n19_20 1k
C19_19 n19_19 0 1n
D19_19 n19_19 0 DGRID
Rh20_19 n20_19 n21_19 1k
Rv20_19 n20_19 n20_20 1k
C20_19 n20_19 0 1n
D20_19 n20_19 0 DGRID
Rh21_19 n21_19 n22_19 1k
Rv21_19 n21_19 n21_20 1k
C21_19 n21_19 0 1n
D21_19 n21_19 0 DGRID
Rh22_19 n22_19 n23_19 1k
Rv22_19 n22_19 n22_20 1k
C22_19 n22_19 0 1n
D22_19 n22_19 0 DGRID
Rv23_19 n23_19 n23_20 1k
C23_19 n23_19 0 1n
D23_19 n23_19 0 DGRID
Rh0_20 n0_20 n1_20 1k
Rv0_20 n0_20 n0_21 1k
C0_20 n0_20 0 1n
D0_20 n0_20 0 DGRID
Rh1_20 n1_20 n2_20 1k
Rv1_20 n1_20 n1_21 1k
C1_20 n1_20 0 1n
D1_20 n1_20 0 DGRID
Rh2_20 n2_20 n3_20 1k
Rv2_20 n2_20 n2_21 1k
C2_20 n2_20 0 1n
D2_20 n2_20 0 DGRID
Rh3_20 n3_20 n4_20 1k
Rv3_20 n3_20 n3_21 1k
C3_20 n3_20 0 1n
D3_20 n3_20 0 DGRID
Rh4_20 n4_20 n5_20 1k
Rv4_20 n4_20 n4_21 1k
C4_20 n4_20 0 1n
D4_20 n4_20 0 DGRID
Rh5_20 n5_20 n6_20 1k
Rv5_20 n5_20 n5_21 1k
C5_20 n5_20 0 1n
D5_20 n5_20 0 DGRID
Rh6_20 n6_20 n7_20 1k
Rv6_20 n6_20 n6_21 1k
C6_20 n6_20 0 1n
D6_20 n6_20 0 DGRID
Rh7_20 n7_20 n8_20 1k
Rv7_20 n7_20 n7_21 1k
C7_20 n7_20 0 1n
D7_20 n7_20 0 DGRID
Rh8_20 n8_20 n9_20 1k
Rv8_20 n8_20 n8_21 1k
C8_20 n8_20 0 1n
D8_20 n8_20 0 DGRID
Rh9_20 n9_20 n10_20 1k
Rv9_20 n9_20 n9_21 1k
C9_20 n9_20 0 1n
D9_20 n9_20 0 DGRID
Rh10_20 n10_20 n11_20 1k
Rv10_20 n10_20 n10_21 1k
C10_20 n10_20 0 1n
D10_20 n10_20 0 DGRID
Rh11_20 n11_20 n12_20 1k
Rv11_20 n11_20 n11_21 1k
C11_20 n11_20 0 1n
D11_20 n11_20 0 DGRID
Rh12_20 n12_20 n13_20 1k
Rv12_20 n12_20 n12_21 1k
C12_20 n12_20 0 1n
D12_20 n12_20 0 DGRID
Rh13_20 n13_20 n14_20 1k
Rv13_20 n13_20 n13_21 1k
C13_20 n13_20 0 1n
D13_20 n13_20 0 DGRID
Rh14_20 n14_20 n15_20 1k
Rv14_20 n14_20 n14_21 1k
C14_20 n14_20 0 1n
D14_20 n14_20 0 DGRID
Rh15_20 n15_20 n16_20 1k
Rv15_20 n15_20 n15_21 1k
C15_20 n15_20 0 1n
D15_20 n15_20 0 DGRID
Rh16_20 n16_20 n17_20 1k
Rv16_20 n16_20 n16_21 1k
C16_20 n16_20 0 1n
D16_20 n16_20 0 DGRID
Rh17_20 n17_20 n18_20 1k
Rv17_20 n17_20 n17_21 1k
C17_20 n17_20 0 1n
D17_20 n17_20 0 DGRID
Rh18_20 n18_20 n19_20 1k
Rv18_20 n18_20 n18_21 1k
C18_20 n18_20 0 1n
D18_20 n18_20 0 DGRID
Rh19_20 n19_20 n20_20 1k
Rv19_20 n19_20 n19_21 1k
C19_20 n19_20 0 1n
D19_20 n19_20 0 DGRID
Rh20_20 n20_20 n21_20 1k
Rv20_20 n20_20 n20_21 1k
C20_20 n20_20 0 1n
D20_20 n20_20 0 DGRID
Rh21_20 n21_20 n22_20 1k
Rv21_20 n21_20 n21_21 1k
C21_20 n21_20 0 1n
D21_20 n21_20 0 DGRID
Rh22_20 n22_20 n23_20 1k
Rv22_20 n22_20 n22_21 1k
C22_20 n22_20 0 1n
D22_20 n22_20 0 DGRID
Rv23_20 n23_20 n23_21 1k
C23_20 n23_20 0 1n
D23_20 n23_20 0 DGRID
Rh0_21 n0_21 n1_21 1k
Rv0_21 n0_21 n0_22 1k
C0_21 n0_21 0 1n
D0_21 n0_21 0 DGRID
Rh1_21 n1_21 n2_21 1k
Rv1_21 n1_21 n1_22 1k
C1_21 n1_21 0 1n
D1_21 n1_21 0 DGRID
Rh2_21 n2_21 n3_21 1k
Rv2_21 n2_21 n2_22 1k
C2_21 n2_21 0 1n
D2_21 n2_21 0 DGRID
Rh3_21 n3_21 n4_21 1k
Rv3_21 n3_21 n3_22 1k
C3_21 n3_21 0 1n
D3_21 n3_21 0 DGRID
Rh4_21 n4_21 n5_21 1k
Rv4_21 n4_21 n4_22 1k
C4_21 n4_21 0 1n
D4_21 n4_21 0 DGRID
Rh5_21 n5_21 n6_21 1k
Rv5_21 n5_21 n5_22 1k
C5_21 n5_21 0 1n
D5_21 n5_21 0 DGRID
Rh6_21 n6_21 n7_21 1k
Rv6_21 n6_21 n6_22 1k
C6_21 n6_21 0 1n
D6_21 n6_21 0 DGRID
Rh7_21 n7_21 n8_21 1k
Rv7_21 n7_21 n7_22 1k
C7_21 n7_21 0 1n
D7_21 n7_21 0 DGRID
Rh8_21 n8_21 n9_21 1k
Rv8_21 n8_21 n8_22 1k
C8_21 n8_21 0 1n
D8_21 n8_21 0 DGRID
Rh9_21 n9_21 n10_21 1k
Rv9_21 n9_21 n9_22 1k
C9_21 n9_21 0 1n
D9_21 n9_21 0 DGRID
Rh10_21 n10_21 n11_21 1k
Rv10_21 n10_21 n10_22 1k
C10_21 n10_21 0 1n
D10_21 n10_21 0 DGRID
Rh11_21 n11_21 n12_21 1k
Rv11_21 n11_21 n11_22 1k
C11_21 n11_21 0 1n
D11_21 n11_21 0 DGRID
Rh12_21 n12_21 n13_21 1k
Rv12_21 n12_21 n12_22 1k
C12_21 n12_21 0 1n
D12_21 n12_21 0 DGRID
Rh13_21 n13_21 n14_21 1k
Rv13_21 n13_21 n13_22 1k
C13_21 n13_21 0 1n
D13_21 n13_21 0 DGRID
Rh14_21 n14_21 n15_21 1k
Rv14_21 n14_21 n14_22 1k
C14_21 n14_21 0 1n
D14_21 n14_21 0 DGRID
Rh15_21 n15_21 n16_21 1k
Rv15_21 n15_21 n15_22 1k
C15_21 n15_21 0 1n
D15_21 n15_21 0 DGRID
Rh16_21 n16_21 n17_21 1k
Rv16_21 n16_21 n16_22 1k
C16_21 n16_21 0 1n
D16_21 n16_21 0 DGRID
Rh17_21 n17_21 n18_21 1k
Rv17_21 n17_21 n17_22 1k
C17_21 n17_21 0 1n
D17_21 n17_21 0 DGRID
Rh18_21 n18_21 n19_21 1k
Rv18_21 n18_21 n18_22 1k
C18_21 n18_21 0 1n
D18_21 n18_21 0 DGRID
Rh19_21 n19_21 n20_21 1k
Rv19_21 n19_21 n19_22 1k
C19_21 n19_21 0 1n
D19_21 n19_21 0 DGRID
Rh20_21 n20_21 n21_21 1k
Rv20_21 n20_21 n20_22 1k
C20_21 n20_21 0 1n
D20_21 n20_21 0 DGRID
Rh21_21 n21_21 n22_21 1k
Rv21_21 n21_21 n21_22 1k
C21_21 n21_21 0 1n
D21_21 n21_21 0 DGRID
Rh22_21 n22_21 n23_21 1k
Rv22_21 n22_21 n22_22 1k
C22_21 n22_21 0 1n
D22_21 n22_21 0 DGRID
Rv23_21 n23_21 n23_22 1k
C23_21 n23_21 0 1n
D23_21 n23_21 0 DGRID
Rh0_22 n0_22 n1_22 1k
Rv0_22 n0_22 n0_23 1k
C0_22 n0_22 0 1n
D0_22 n0_22 0 DGRID
Rh1_22 n1_22 n2_22 1k
Rv1_22 n1_22 n1_23 1k
C1_22 n1_22 0 1n
D1_22 n1_22 0 DGRID
Rh2_22 n2_22 n3_22 1k
Rv2_22 n2_22 n2_23 1k
C2_22 n2_22 0 1n
D2_22 n2_22 0 DGRID
Rh3_22 n3_22 n4_22 1k
Rv3_22 n3_22 n3_23 1k
C3_22 n3_22 0 1n
D3_22 n3_22 0 DGRID
Rh4_22 n4_22 n5_22 1k
Rv4_22 n4_22 n4_23 1k
C4_22 n4_22 0 1n
D4_22 n4_22 0 DGRID
Rh5_22 n5_22 n6_22 1k
Rv5_22 n5_22 n5_23 1k
C5_22 n5_22 0 1n
D5_22 n5_22 0 DGRID
Rh6_22 n6_22 n7_22 1k
Rv6_22 n6_22 n6_23 1k
C6_22 n6_22 0 1n
D6_22 n6_22 0 DGRID
Rh7_22 n7_22 n8_22 1k
Rv7_22 n7_22 n7_23 1k
C7_22 n7_22 0 1n
D7_22 n7_22 0 DGRID
Rh8_22 n8_22 n9_22 1k
Rv8_22 n8_22 n8_23 1k
C8_22 n8_22 0 1n
D8_22 n8_22 0 DGRID
Rh9_22 n9_22 n10_22 1k
Rv9_22 n9_22 n9_23 1k
C9_22 n9_22 0 1n
D9_22 n9_22 0 DGRID
Rh10_22 n10_22 n11_22 1k
Rv10_22 n10_22 n10_23 1k
C10_22 n10_22 0 1n
D10_22 n10_22 0 DGRID
Rh11_22 n11_22 n12_22 1k
Rv11_22 n11_22 n11_23 1k
C11_22 n11_22 0 1n
D11_22 n11_22 0 DGRID
Rh12_22 n12_22 n13_22 1k
Rv12_22 n12_22 n12_23 1k
C12_22 n12_22 0 1n
D12_22 n12_22 0 DGRID
Rh13_22 n13_22 n14_22 1k
Rv13_22 n13_22 n13_23 1k
C13_22 n13_22 0 1n
D13_22 n13_22 0 DGRID
Rh14_22 n14_22 n15_22 1k
Rv14_22 n14_22 n14_23 1k
C14_22 n14_22 0 1n
D14_22 n14_22 0 DGRID
Rh15_22 n15_22 n16_22 1k
Rv15_22 n15_22 n15_23 1k
C15_22 n15_22 0 1n
D15_22 n15_22 0 DGRID
Rh16_22 n16_22 n17_22 1k
Rv16_22 n16_22 n16_23 1k
C16_22 n16_22 0 1n
D16_22 n16_22 0 DGRID
Rh17_22 n17_22 n18_22 1k
Rv17_22 n17_22 n17_23 1k
C17_22 n17_22 0 1n
D17_22 n17_22 0 DGRID
Rh18_22 n18_22 n19_22 1k
Rv18_22 n18_22 n18_23 1k
C18_22 n18_22 0 1n
D18_22 n18_22 0 DGRID
Rh19_22 n19_22 n20_22 1k
Rv19_22 n19_22 n19_23 1k
C19_22 n19_22 0 1n
D19_22 n19_22 0 DGRID
Rh20_22 n20_22 n21_22 1k
Rv20_22 n20_22 n20_23 1k
C20_22 n20_22 0 1n
D20_22 n20_22 0 DGRID
Rh21_22 n21_22 n22_22 1k
Rv21_22 n21_22 n21_23 1k
C21_22 n21_22 0 1n
D21_22 n21_22 0 DGRID
Rh22_22 n22_22 n23_22 1k
Rv22_22 n22_22 n22_23 1k
C22_22 n22_22 0 1n
D22_22 n22_22 0 DGRID
Rv23_22 n23_22 n23_23 1k
C23_22 n23_22 0 1n
D23_22 n23_22 0 DGRID
Rh0_23 n0_23 n1_23 1k
C0_23 n0_23 0 1n
D0_23 n0_23 0 DGRID
Rh1_23 n1_23 n2_23 1k
C1_23 n1_23 0 1n
D1_23 n1_23 0 DGRID
Rh2_23 n2_23 n3_23 1k
C2_23 n2_23 0 1n
D2_23 n2_23 0 DGRID
Rh3_23 n3_23 n4_23 1k
C3_23 n3_23 0 1n
D3_23 n3_23 0 DGRID
Rh4_23 n4_23 n5_23 1k
C4_23 n4_23 0 1n
D4_23 n4_23 0 DGRID
Rh5_23 n5_23 n6_23 1k
C5_23 n5_23 0 1n
D5_23 n5_23 0 DGRID
Rh6_23 n6_23 n7_23 1k
C6_23 n6_23 0 1n
D6_23 n6_23 0 DGRID
Rh7_23 n7_23 n8_23 1k
C7_23 n7_23 0 1n
D7_23 n7_23 0 DGRID
Rh8_23 n8_23 n9_23 1k
C8_23 n8_23 0 1n
D8_23 n8_23 0 DGRID
Rh9_23 n9_23 n10_23 1k
C9_23 n9_23 0 1n
D9_23 n9_23 0 DGRID
Rh10_23 n10_23 n11_23 1k
C10_23 n10_23 0 1n
D10_23 n10_23 0 DGRID
Rh11_23 n11_23 n12_23 1k
C11_23 n11_23 0 1n
D11_23 n11_23 0 DGRID
Rh12_23 n12_23 n13_23 1k
C12_23 n12_23 0 1n
D12_23 n12_23 0 DGRID
Rh13_23 n13_23 n14_23 1k
C13_23 n13_23 0 1n
D13_23 n13_23 0 DGRID
Rh14_23 n14_23 n15_23 1k
C14_23 n14_23 0 1n
D14_23 n14_23 0 DGRID
Rh15_23 n15_23 n16_23 1k
C15_23 n15_23 0 1n
D15_23 n15_23 0 DGRID
Rh16_23 n16_23 n17_23 1k
C16_23 n16_23 0 1n
D16_23 n16_23 0 DGRID
Rh17_23 n17_23 n18_23 1k
C17_23 n17_23 0 1n
D17_23 n17_23 0 DGRID
Rh18_23 n18_23 n19_23 1k
C18_23 n18_23 0 1n
D18_23 n18_23 0 DGRID
Rh19_23 n19_23 n20_23 1k
C19_23 n19_23 0 1n
D19_23 n19_23 0 DGRID
Rh20_23 n20_23 n21_23 1k
C20_23 n20_23 0 1n
D20_23 n20_23 0 DGRID
Rh21_23 n21_23 n22_23 1k
C21_23 n21_23 0 1n
D21_23 n21_23 0 DGRID
Rh22_23 n22_23 n23_23 1k
C22_23 n22_23 0 1n
D22_23 n22_23 0 DGRID
C23_23 n23_23 0 1n
D23_23 n23_23 0 DGRID
Rreturn n23_23 0 1k
.op
.end
