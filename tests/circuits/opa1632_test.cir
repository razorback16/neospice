OPA1632 Fully-Differential Amplifier Test
* Supply: +/-5V, Gain=1, VOCM=0V
* Pin order: VIN- VOCM V+ VOUT+ VOUT- V- EN VIN+
*
.include opa1632.lib
*
* Power supplies
VCC vcc 0 DC 5
VEE vee 0 DC -5
*
* Input signal (single-ended to differential)
Vin inp 0 DC 0.1 AC 1
*
* Gain-setting resistors: unity gain (Rf/Rg = 1)
* VIN+ (pin 8) through Rg to input
Rg_p inp vinp 392
Rf_p outp vinp 392
*
* VIN- (pin 1) to ground through Rg
Rg_n 0 vinn 392
Rf_n outn vinn 392
*
* VOCM (pin 2) to ground for 0V common mode
R_vocm vocm 0 100
*
* EN (pin 7) tied to V+ to enable
R_en vcc en 10k
*
* OPA1632: VIN-(1) VOCM(2) V+(3) VOUT+(4) VOUT-(5) V-(6) EN(7) VIN+(8)
X1 vinn vocm vcc outp outn vee en vinp OPA1632
*
* Load
Rload outp outn 600
*
.op
.ac dec 10 1 100e6
.end
