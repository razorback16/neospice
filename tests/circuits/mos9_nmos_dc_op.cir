MOS9 NMOS DC Operating Point
Vdd vdd 0 5
Vgs gate 0 2.0
Rd vdd drain 1k
M1 drain gate 0 0 NMOD W=10u L=1u
.model NMOD NMOS LEVEL=9 VTO=0.7 KP=110U GAMMA=0.4 PHI=0.65
+ ETA=0.1 THETA=0.05 KAPPA=0.5 DELTA=0.5 NFS=1e10
.op
.end
