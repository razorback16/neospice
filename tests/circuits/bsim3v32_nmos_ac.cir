BSIM3v32 NMOS Common-Source Amplifier AC Analysis
VDD vdd 0 DC 1.8
VG gate 0 DC 0.9 AC 1
RD vdd drain 5k
M1 drain gate 0 0 NMOD W=10u L=100n
.model NMOD NMOS LEVEL=49 VERSION=3.24 TNOM=27
+ TOX=9E-9 VTH0=0.5 K1=0.53 K2=-0.03
+ NCH=2.3E17 NSUB=1E16
+ U0=300 VSAT=1.5E5
+ UA=-1.4E-9 UB=2.3E-18 UC=-4.6E-11
+ RDSW=200 PRWG=0.5 PRWB=0.2
+ WR=1 WINT=5E-9 LINT=2E-8
+ DWG=-2E-8 DWB=1E-8
+ VOFF=-0.1 NFACTOR=1.5 ETA0=0.08 ETAB=-0.07
+ DSUB=0.56 PCLM=1.3 PDIBLC1=0.39 PDIBLC2=0.0086
+ DROUT=0.56 PSCBE1=4.24E8 PSCBE2=1E-5 PVAG=0.1
+ DELTA=0.01 ALPHA0=0 BETA0=30
+ CGSO=2.4E-10 CGDO=2.4E-10 CGBO=1E-11
.ac dec 10 1k 100g
.end
