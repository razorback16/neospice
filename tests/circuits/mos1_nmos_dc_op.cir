MOS1 NMOS DC Operating Point
Vdd vdd 0 5
Vgs gate 0 2.0
Rd vdd drain 1k
M1 drain gate 0 0 NMOD W=10u L=1u
.model NMOD NMOS LEVEL=1 VTO=0.7 KP=110U GAMMA=0.4 PHI=0.65
.op
.end
