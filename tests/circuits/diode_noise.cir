Diode noise test
V1 in 0 DC 0.7 AC 1
R1 in anode 1k
D1 anode 0 DMOD
.model DMOD D(Is=1e-14 N=1)
.noise V(anode) V1 dec 10 100 1meg
.end
