CMOS Inverter with drain/source and gate resistance
VDD vdd 0 1.8
VIN in 0 PULSE(0 1.8 100p 100p 100p 1n 2.2n)
M1 out in vdd vdd PMOD W=2u L=100n
M2 out in 0 0 NMOD W=1u L=100n
.model NMOD NMOS LEVEL=14 VTH0=0.4 U0=0.04 TOXE=2e-9 RDSMOD=1 RDSW=200 RGATEMOD=1 RSHG=10
.model PMOD PMOS LEVEL=14 VTH0=-0.4 U0=0.02 TOXE=2e-9 RDSMOD=1 RDSW=200 RGATEMOD=1 RSHG=10
.tran 10p 4n
.end
