HiSIM2 NMOS AC Small-Signal
Vdd vdd 0 1.8
Vin gate 0 0.9 AC 1
Rd vdd drain 1k
M1 drain gate 0 0 NMOD W=10u L=1u
.model NMOD NMOS LEVEL=68 TOX=3.0e-9 NSUBC=5.0e17 VFBC=-1.0
.ac dec 10 100 10meg
.end
