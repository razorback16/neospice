BSIM3 CMOS Inverter Transient
VDD vdd 0 1.8
VIN in 0 PULSE(0 1.8 0 100p 100p 5n 10n)
M1 out in vdd vdd PMOD W=2u L=100n
M2 out in 0 0 NMOD W=1u L=100n
CL out 0 10f
.model NMOD NMOS LEVEL=49 VERSION=3.3 TNOM=27
+ TOX=9E-9 VTH0=0.5 K1=0.53 K2=-0.03
+ NCH=2.3E17 NSUB=1E16
+ U0=300 VSAT=1.5E5
+ UA=-1.4E-9 UB=2.3E-18 UC=-4.6E-11
+ RDSW=200 PRWG=0.5 PRWB=0.2
+ WR=1 WINT=5E-9 LINT=2E-8
+ DWG=-2E-8 DWB=1E-8
+ VOFF=-0.1 NFACTOR=1.5 ETA0=0.08 ETAB=-0.07
+ DSUB=0.56 PCLM=1.3 PDIBLC1=0.39 PDIBLC2=0.0086
+ DROUT=0.56 PSCBE1=4.24E8 PSCBE2=1E-5 PVAG=0.1
+ DELTA=0.01 ALPHA0=0 BETA0=30
+ CGSO=2.4E-10 CGDO=2.4E-10 CGBO=1E-11
.model PMOD PMOS LEVEL=49 VERSION=3.3 TNOM=27
+ TOX=9E-9 VTH0=-0.5 K1=0.53 K2=-0.03
+ NCH=2.3E17 NSUB=1E16
+ U0=150 VSAT=1.2E5
+ UA=-1.4E-9 UB=2.3E-18 UC=-4.6E-11
+ RDSW=400 PRWG=0.5 PRWB=0.2
+ WR=1 WINT=5E-9 LINT=2E-8
+ DWG=-2E-8 DWB=1E-8
+ VOFF=-0.1 NFACTOR=1.5 ETA0=0.08 ETAB=-0.07
+ DSUB=0.56 PCLM=1.3 PDIBLC1=0.39 PDIBLC2=0.0086
+ DROUT=0.56 PSCBE1=4.24E8 PSCBE2=1E-5 PVAG=0.1
+ DELTA=0.01 ALPHA0=0 BETA0=30
+ CGSO=2.4E-10 CGDO=2.4E-10 CGBO=1E-11
.tran 10p 20n
.end
