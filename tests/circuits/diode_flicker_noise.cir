Diode flicker noise test (1/f)
V1 in 0 DC 0.65 AC 1
R1 in anode 1k
D1 anode 0 DMOD
.model DMOD D(Is=1e-14 N=1 Kf=1e-14 Af=1 Ef=1)
.noise V(anode) V1 dec 10 1 1meg
.end
