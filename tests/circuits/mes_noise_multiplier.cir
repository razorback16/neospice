MES multiplier noise comparison
VDD supply 0 3
RL supply out 100
VGS gate 0 -0.5 AC 1
Z1 out gate 0 MESMOD M=3
.model MESMOD NMF VTO=-2 BETA=2.5m ALPHA=2 LAMBDA=0.04 RD=12 RS=7 CGS=1p CGD=0.8p KF=1e-16 AF=1.3
.noise V(out) VGS DEC 3 1 1G
.end
