MOS3 NMOS DC Operating Point
Vdd vdd 0 5
Vgs gate 0 2.0
Rd vdd drain 1k
M1 drain gate 0 0 NMOD W=10u L=1u
.model NMOD NMOS LEVEL=3 VTO=0.7 KP=110U GAMMA=0.4 PHI=0.65 THETA=0.1 ETA=0.1 KAPPA=0.5
.op
.end
