MOS1 NMOS IV Curve Sweep
Vds drain 0 DC 0
Vgs gate 0 DC 2.5
M1 drain gate 0 0 NMOD W=10u L=1u
.model NMOD NMOS LEVEL=1 VTO=0.7 KP=110U GAMMA=0.4 PHI=0.65
.dc Vds 0 5 0.05
.end
