NMOS NQS AC Analysis — acnqsMod=1
VDD vdd 0 DC 1.8
VG gate 0 DC 0.9 AC 1
RD vdd drain 1k
M1 drain gate 0 0 NMOD W=10u L=1u
.model NMOD NMOS LEVEL=14 VTH0=0.4 U0=0.04 TOXE=2e-9
+ ACNQSMOD=1
.ac dec 10 1k 100g
.end
