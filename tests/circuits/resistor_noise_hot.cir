Resistor divider noise at T=100 degC
V1 in 0 DC 1 AC 1
R1 in out 10k
R2 out 0 10k
.options temp=100
.noise V(out) V1 dec 10 1 1meg
.end
