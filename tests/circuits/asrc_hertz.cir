ASRC HERTZ parse test
V1 in 0 1.0
B1 out 0 V={V(in)+0*HERTZ}
R1 out 0 1k
.op
.end
