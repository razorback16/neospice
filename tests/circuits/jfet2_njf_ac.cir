JFET2 NJF AC Small-Signal
* Common-source NJF amplifier AC analysis with JFET2 LEVEL=2
Vdd vdd 0 5
Rd vdd drain 1k
J1 drain gate 0 JMOD
Vg gate 0 DC -0.5 AC 1
.model JMOD NJF LEVEL=2 VTO=-2 BETA=1e-4 LAMBDA=0.02 IS=1e-14 RD=10 RS=10
+ CGS=5e-12 CGD=1e-12 PB=1.0 FC=0.5
.ac dec 10 100 1G
.end
