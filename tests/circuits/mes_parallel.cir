MES multiplier compared with explicit parallel instances
VDDM dm 0 1.5
VDDP dp 0 1.5
VG gate 0 PULSE(-0.5 -0.2 100n 20n 20n 400n 1u) AC 1
ZM dm gate 0 MF AREA=2.5 M=3
ZP1 dp gate 0 MF AREA=2.5
ZP2 dp gate 0 MF AREA=2.5
ZP3 dp gate 0 MF AREA=2.5
.model MF NMF VTO=-2 BETA=2.5m ALPHA=2 LAMBDA=0.04 RD=12 RS=7 CGS=1p CGD=0.8p KF=1e-16 AF=1.3
.op
.ac DEC 3 1 1G
.tran 10n 2u
.end
