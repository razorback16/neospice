RC lowpass noise test
V1 in 0 DC 0 AC 1
R1 in out 10k
C1 out 0 10n
.noise V(out) V1 dec 10 100 10meg
.end
