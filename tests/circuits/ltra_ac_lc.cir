LTRA LC frequency response
V1 drive 0 DC 0 AC 1
Rs drive in 50
O1 in 0 out 0 TMOD
Rl out 0 50
.model TMOD LTRA L=250n C=100p LEN=1
.ac DEC 4 1k 10g
.end
