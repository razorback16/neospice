NMOS with RDSMOD (drain/source resistance)
V1 drain 0 1.0
V2 gate 0 1.0
M1 drain gate 0 0 NMOD W=1u L=100n
.model NMOD NMOS LEVEL=14 VTH0=0.4 U0=0.04 TOXE=2e-9 RDSMOD=1 RDSW=200
.op
.end
