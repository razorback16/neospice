* PULSE with omitted TR/TF/PW/PER — should use ngspice defaults
V1 in 0 PULSE(0 5 1u)
R1 in 0 1k
.tran 1u 20u
.end
