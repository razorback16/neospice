HiSIM_HV NMOS Noise Analysis
Vdd vdd 0 3.3
Vin gate 0 1.5 AC 1
Rd vdd drain 1k
M1 drain gate 0 0 NMOD W=10u L=5u
.model NMOD NMOS LEVEL=73
.noise V(drain) Vin dec 10 100 10meg
.end
