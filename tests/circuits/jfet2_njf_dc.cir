JFET2 NJF DC Operating Point
* Common-source NJF amplifier with JFET2 (Parker-Skellern) LEVEL=2 model
Vdd vdd 0 5
Rd vdd drain 1k
J1 drain gate 0 JMOD
Vg gate 0 DC -0.5
.model JMOD NJF LEVEL=2 VTO=-2 BETA=1e-4 LAMBDA=0.02 IS=1e-14 RD=10 RS=10
+ CGS=5e-12 CGD=1e-12 PB=1.0 FC=0.5
.op
.end
