Diode DC Sweep
V1 in 0 DC 0
R1 in out 1k
D1 out 0 DMOD
.model DMOD D(IS=1e-14 N=1)
.dc V1 -1 1 0.01
.end
