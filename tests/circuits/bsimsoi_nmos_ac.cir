BSIMSOI NMOS AC Small-Signal
Vdd vdd 0 1.8
Vin gate 0 0.9 AC 1
Rd vdd drain 1k
M1 drain gate 0 0 0 0 NMOD W=10u L=1u
.model NMOD NMOS LEVEL=10
.ac dec 10 100 10meg
.end
