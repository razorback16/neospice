MES state_offset noise comparison
VDD supply 0 3
RL supply out 100
VGS gate 0 -0.5 AC 1
VD aux 0 0.6
D1 aux 0 DMOD
.model DMOD D(IS=1e-14)
Z0 aux gate 0 BACKMOD AREA=0.5 M=2
.model BACKMOD NMF VTO=-1.5 BETA=1m RD=3 RS=4 KF=1e-18
Z1 out gate 0 MESMOD
.model MESMOD NMF VTO=-2 BETA=2.5m ALPHA=2 LAMBDA=0.04 RD=12 RS=7 CGS=1p CGD=0.8p KF=1e-16 AF=1.3
.noise V(out) VGS DEC 3 1 1G
.end
