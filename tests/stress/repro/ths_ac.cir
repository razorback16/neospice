THS4131 unity gain
.include ../../circuits/ths4131.lib
.param rf=1k
VCC vcc 0 DC 5
VEE vee 0 DC -5
Vin inp 0 DC 0.1 AC 1
Rg1 inp in_p 1k
Rf1 out_p in_p {rf}
Rg2 0 in_n 1k
Rf2 out_n in_n {rf}
Vvocm vocm 0 DC 0
X1 in_p in_n vcc vee out_p out_n vocm THS4131
Rload1 out_p 0 1k
Rload2 out_n 0 1k
.ac dec 10 1 100e6
.end
